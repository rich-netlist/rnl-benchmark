simulator lang=spectre
// @RNL(type="header") {
//   @VERSION("0.4");
//   @USE-PACKAGE(name="rnl-std-style", version="0.4");
//   @USE-PACKAGE(name="rnl-std-basic", version="0.4");
//   @USE-PACKAGE(name="rnl-std-semiconductors", version="0.4");
//   @USE-PACKAGE(name="rnl-std-no-labels", version="0.4");
//   @USE-PACKAGE(name="analog-canvas-extensions", version="0.7")
// }

subckt Main (VDD VSS Iout)
M1 (Iout net2 net0 VSS) sky130_fd_pr__nfet_01v8 l=0.15 w=1 nf=1 m=1
M2 (net0 net0 VSS VSS) sky130_fd_pr__nfet_01v8 l=0.15 w=1 nf=1 m=1
M3 (net3 net2 net1 VSS) sky130_fd_pr__nfet_01v8 l=0.15 w=1 nf=1 m=1
M4 (net1 net0 VSS VSS) sky130_fd_pr__nfet_01v8 l=0.15 w=1 nf=1 m=1
R1 (VDD net3) resistor r=1k
R2 (net0 VSS) resistor r=1k
// @RNL(author="analog-canvas") {
//   $CANVAS_TYPESETTING @ATTACH #(level);
//   #M1 @SET-SYMBOL(terminals=[[1, "d"], [2, "g"], [3, "s"]]) $NMOS => @PLACE(33, -27) => @ORIENT("R0");
//   #M2 @SET-SYMBOL(terminals=[[1, "d"], [2, "g"], [3, "s"]]) $NMOS => @PLACE(33, -33) => @ORIENT("R0");
//   #M3 @SET-SYMBOL(terminals=[[1, "d"], [2, "g"], [3, "s"]]) $NMOS => @PLACE(19, -27) => @ORIENT("MY");
//   #M4 @SET-SYMBOL(terminals=[[1, "d"], [2, "g"], [3, "s"]]) $NMOS => @PLACE(19, -33) => @ORIENT("MY");
//   #R1 @SET-SYMBOL $RESISTOR => @PLACE(19, -24) => @ORIENT("R0");
//   $GROUND @ATTACH &VSS(p) => @SET-SYMBOL $GROUND_SYMBOL => @PLACE(26, -39) => @ORIENT("R0") => %gnd1;
//   #R2 @SET-SYMBOL $RESISTOR => @PLACE(28, -36) => @ORIENT("R0");
//   $IO_PORT @ATTACH &Iout(p) => @SET-SYMBOL $IO_PORT_SYMBOL => @PLACE(33, -25) => @ORIENT("R270") => %port1;
//   $SUPPLY @ATTACH &VDD(p) => @SET-SYMBOL $SUPPLY_SYMBOL => @PLACE(19, -22) => @ORIENT("R0") => %vdd1;
//   %j1 = (26, -33);
//   %j2 = (33, -30);
//   %j3 = (28, -39);
//   %j4 = (28, -33);
//   &net1 @WIRE(mode="straight") {#M3:3 #M4:1};
//   &net2 @WIRE(mode="straight") {#M3:2 #M1:2};
//   &net0 @WIRE(mode="straight") {#M4:2 %j1};
//   &net0 @WIRE(mode="straight") {%j1 %j4};
//   &net0 @WIRE(mode="straight") {%j1 (26, -30) %j2};
//   &net0 @WIRE(mode="straight") {%j4 #R2:1};
//   &net0 @WIRE(mode="straight") {%j4 #M2:2};
//   &net0 @WIRE(mode="straight") {#M1:3 %j2};
//   &net0 @WIRE(mode="straight") {%j2 #M2:1};
//   &VSS @WIRE(mode="straight") {#M4:3 (19, -39) %gnd1::pin};
//   &VSS @WIRE(mode="straight") {%gnd1::pin %j3};
//   &VSS @WIRE(mode="straight") {#R2:2 %j3};
//   &VSS @WIRE(mode="straight") {%j3 (33, -39) #M2:3};
//   &net3 @WIRE(mode="straight") {#M3:1 #R1:2};
//   $JUNCTION @ATTACH (26, -39)(p) => @PLACE(26, -39) => %dot1;
//   $JUNCTION @ATTACH %j3(p) => @PLACE(28, -39) => %dot2;
//   &VDD @WIRE(mode="straight") {#R1:1 %vdd1::pin};
//   &Iout @WIRE(mode="straight") {#M1:1 %port1::pin};
//   $JUNCTION @ATTACH %j1(p) => @PLACE(26, -33) => %dot3;
//   $JUNCTION @ATTACH %j4(p) => @PLACE(28, -33) => %dot4;
//   $JUNCTION @ATTACH %j2(p) => @PLACE(33, -30) => %dot5;
//   #M1
//       @TEXT("\textbf{\textit{M}}_{\textbf{1}}", key="name", dx=1, dy=-1, halign="start", valign="baseline", size=1.5116,
//       bold=false, textvisible=true);
//   $CANVAS_LABEL @ATTACH(bind="name") #M1::name(label);
//   #M2
//       @TEXT("\textbf{\textit{M}}_{\textbf{2}}", key="name", dx=1, dy=-1, halign="start", valign="baseline", size=1.5116,
//       bold=false, textvisible=true);
//   $CANVAS_LABEL @ATTACH(bind="name") #M2::name(label);
//   #M3
//       @TEXT("\textbf{\textit{M}}_{\textbf{3}}", key="name", dx=-1, dy=-1, halign="end", valign="baseline", size=1.5116,
//       bold=false, textvisible=true);
//   $CANVAS_LABEL @ATTACH(bind="name") #M3::name(label);
//   #M4
//       @TEXT("\textbf{\textit{M}}_{\textbf{4}}", key="name", dx=-1, dy=-1, halign="end", valign="baseline", size=1.5116,
//       bold=false, textvisible=true);
//   $CANVAS_LABEL @ATTACH(bind="name") #M4::name(label);
//   #R1
//       @TEXT("\textbf{\textit{R}}", key="name", dx=2, dy=-1, halign="start", valign="baseline", size=1.5116, bold=false,
//       textvisible=true);
//   #R2
//       @TEXT("\textbf{\textit{R/2}}", key="name", dx=-4, dy=-0.5, halign="start", valign="baseline", size=1.5116, bold=false,
//       textvisible=true);
//   %port1
//       @TEXT("\textbf{\textit{I}}_{\textbf{out}}", key="netname", dx=-1, dy=2, halign="start", valign="baseline", size=1.5116,
//       bold=false, textvisible=true);
//   $CANVAS_LABEL @ATTACH(bind="port") %port1::netname(label);
//   %vdd1 @TEXT("\textbf{\textit{V}}_{\textbf{DD}}", dx=2, dy=1, size=1.5116, bold=false) => %power1;
//   $CANVAS_LABEL @ATTACH(bind="port") %power1(label);
//   (30, -15) @TEXT("Iout=(VDD-Vgs3-Vgs2)/R+Vgs2/(R/2)", halign="middle", size=1.5116, bold=true) => %text1;
//   $CANVAS_TYPOGRAPHY @ATTACH(token="label") %text1(text);
//   (20, -17.7) @TEXT("=VDD/R", halign="middle", size=1.5116, bold=true) => %text2;
//   $CANVAS_TYPOGRAPHY @ATTACH(token="label") %text2(text);
//   (32.5, -17.7) @TEXT("if Vgs3=Vgs2", halign="middle", size=1.5116, bold=true) => %text3;
//   $CANVAS_TYPOGRAPHY @ATTACH(token="label") %text3(text);
//   %vdd1 @TEXT("${p}", key="netname", textvisible=false)
// }
ends Main
