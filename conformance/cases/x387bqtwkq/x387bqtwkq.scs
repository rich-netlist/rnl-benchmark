simulator lang=spectre
// @RNL(type="header") {
//   @VERSION("0.4");
//   @USE-PACKAGE(name="rnl-std-style", version="0.4");
//   @USE-PACKAGE(name="rnl-std-basic", version="0.4");
//   @USE-PACKAGE(name="rnl-std-semiconductors", version="0.4");
//   @USE-PACKAGE(name="rnl-std-no-labels", version="0.4");
//   @USE-PACKAGE(name="analog-canvas-extensions", version="0.7")
// }

subckt dut (VDD VSS VIN VOUT)
M1 (VOUT VIN net0 VSS) sky130_fd_pr__nfet_01v8 l=0.15 w=1 nf=1 m=1
RD (VDD VOUT) resistor r=1k
RS (net0 VSS) resistor r=1k
// @RNL(author="analog-canvas") {
//   %dut_SYMBOL = @DEFINE-SYMBOL(box=[-6, -4, 6, 4]) {
//     (0, 4) @PIN(terminal="VDD", label="\textbf{\textit{V}}_{\textbf{DD}}", direction="up");
//     (-6, -1) @PIN(terminal="VIN", label="\textbf{\textit{V}}_{\textbf{IN}}", direction="left");
//     (6, -1) @PIN(terminal="VOUT", label="\textbf{\textit{V}}_{\textbf{OUT}}", direction="right");
//     (0, 0) @RECTANGLE(width=10, height=6);
//     @LINE {(0, 4) (0, 3)};
//     @LINE {(-6, -1) (-5, -1)};
//     @LINE {(6, -1) (5, -1)}
//   };
//   # @SET-SYMBOL %dut_SYMBOL;
//   $CANVAS_TYPESETTING @ATTACH(subscript_italic=false) #(level);
//   #M1 @SET-SYMBOL(terminals=[[1, "d"], [2, "g"], [3, "s"]]) $NMOS => @PLACE(41, -32) => @ORIENT("R0");
//   #RD @SET-SYMBOL $RESISTOR => @PLACE(41, -25) => @ORIENT("R0");
//   #RS @SET-SYMBOL $RESISTOR => @PLACE(41, -39) => @ORIENT("R0");
//   $SUPPLY @ATTACH &VDD(p) => @SET-SYMBOL $SUPPLY_SYMBOL => @PLACE(41, -21) => @ORIENT("R0") => %vdd1;
//   $IO_PORT @ATTACH &VIN(p) => @SET-SYMBOL $IO_PORT_SYMBOL => @PLACE(35, -32) => @ORIENT("R0") => %port1;
//   $IO_PORT @ATTACH &VOUT(p) => @SET-SYMBOL $IO_PORT_SYMBOL => @PLACE(45, -29) => @ORIENT("R180") => %port2;
//   $GROUND @ATTACH &VSS(p) => @SET-SYMBOL $GROUND_SYMBOL => @PLACE(41, -42) => @ORIENT("R0") => %gnd1;
//   %j1 = (41, -29);
//   &VIN @WIRE(mode="straight") {#M1:2 %port1::pin};
//   &VOUT @WIRE(mode="straight") {#M1:1 %j1};
//   &VOUT @WIRE(mode="straight") {%j1 #RD:2};
//   &VOUT @WIRE(mode="straight") {%port2::pin %j1};
//   &VDD @WIRE(mode="straight") {#RD:1 %vdd1::pin};
//   &net0 @WIRE(mode="straight") {#M1:3 #RS:1};
//   &VSS @WIRE(mode="straight") {#RS:2 %gnd1::pin};
//   $JUNCTION @ATTACH %j1(p) => @PLACE(41, -29) => %dot1;
//   #M1
//       @TEXT("\textbf{\textit{M}}_{\textbf{1}}", key="name", dx=0.5, dy=-0.5, halign="start", valign="baseline", size=1.5116,
//       bold=false, textvisible=true);
//   $CANVAS_LABEL @ATTACH(bind="name") #M1::name(label);
//   #RD
//       @TEXT("\textbf{\textit{R}}_{\textbf{D}}", key="name", dx=0.9, dy=-0.5, halign="start", valign="baseline", size=1.5116,
//       bold=false, textvisible=true);
//   $CANVAS_LABEL @ATTACH(bind="name") #RD::name(label);
//   #RS
//       @TEXT("\textbf{\textit{R}}_{\textbf{S}}", key="name", dx=0.9, dy=-0.5, halign="start", valign="baseline", size=1.5116,
//       bold=false, textvisible=true);
//   $CANVAS_LABEL @ATTACH(bind="name") #RS::name(label);
//   %vdd1 @TEXT("\textbf{\textit{V}}_{\textbf{DD}}", dx=2, dy=1, size=1.5116, bold=false) => %power1;
//   $CANVAS_LABEL @ATTACH(bind="port") %power1(label);
//   %port1
//       @TEXT("\textbf{\textit{V}}_{\textbf{IN}}", key="netname", dx=-2, dy=-0.5, halign="end", valign="baseline", size=1.5116,
//       bold=false, textvisible=true);
//   $CANVAS_LABEL @ATTACH(bind="port") %port1::netname(label);
//   %port2
//       @TEXT("\textbf{\textit{V}}_{\textbf{OUT}}", key="netname", dx=2, dy=-0.5, halign="start", valign="baseline", size=1.5116,
//       bold=false, textvisible=true);
//   $CANVAS_LABEL @ATTACH(bind="port") %port2::netname(label);
//   %vdd1 @TEXT("${p}", key="netname", textvisible=false)
// }
ends dut
