simulator lang=spectre
// @RNL(type="header") {
//   @VERSION("0.4");
//   @USE-PACKAGE(name="rnl-std-style", version="0.4");
//   @USE-PACKAGE(name="rnl-std-basic", version="0.4");
//   @USE-PACKAGE(name="rnl-std-semiconductors", version="0.4");
//   @USE-PACKAGE(name="rnl-std-no-labels", version="0.4");
//   @USE-PACKAGE(name="analog-canvas-extensions", version="0.7");
//   @USE-PACKAGE(name="rnl-std-rf", version="0.4")
// }

subckt ct_inductor (n1 n2 n3)
parameters l1=1n l2=1n k=0
L1 (n1 n3) inductor l=l1
L2 (n3 n2) inductor l=l2
K12 mutual_inductor coupling=k ind1=L1 ind2=L2
ends ct_inductor

subckt PA (VDD VSS VB inp inn outp outn src)
Cf1 (outp net3) capacitor c=1p
Cf2 (outn net1) capacitor c=1p
LBWa (VDD outp) inductor l=1n
LBWb (VDD outn) inductor l=1n
LBWc (VB net5) inductor l=1n
LBWg (src VSS) inductor l=1n
MP1A (net0 inp src VSS) sky130_fd_pr__nfet_01v8 l=0.15 w=1 nf=1 m=1
MP1B (net2 inn src VSS) sky130_fd_pr__nfet_01v8 l=0.15 w=1 nf=1 m=1
MP2A (outp net4 net0 VSS) sky130_fd_pr__nfet_01v8 l=0.15 w=1 nf=1 m=1
MP2B (outn net4 net2 VSS) sky130_fd_pr__nfet_01v8 l=0.15 w=1 nf=1 m=1
Rc (net5 net4) resistor r=1k
Rf1 (net3 inp) resistor r=1k
Rf2 (net1 inn) resistor r=1k
// @RNL(author="analog-canvas") {
//   %PA_SYMBOL = @DEFINE-SYMBOL(box=[-6, -7, 6, 7]) {
//     (-2, 7) @PIN(terminal="VDD", label="\textbf{\textit{V}}_{\textbf{DD}}", direction="up");
//     (2, 7) @PIN(terminal="VB", label="\textbf{\textit{V}}_{\textbf{B}}", direction="up");
//     (-6, 2) @PIN(terminal="inp", label="\textbf{\textit{inp}}", direction="left");
//     (-6, -2) @PIN(terminal="inn", label="\textbf{\textit{inn}}", direction="left");
//     (6, 2) @PIN(terminal="outp", label="\textbf{\textit{outp}}", direction="right");
//     (6, -2) @PIN(terminal="outn", label="\textbf{\textit{outn}}", direction="right");
//     (0, -7) @PIN(terminal="src", label="\textbf{\textit{src}}", direction="down");
//     (0, 0) @RECTANGLE(width=10, height=12);
//     @LINE {(-2, 7) (-2, 6)};
//     @LINE {(2, 7) (2, 6)};
//     @LINE {(-6, 2) (-5, 2)};
//     @LINE {(-6, -2) (-5, -2)};
//     @LINE {(6, 2) (5, 2)};
//     @LINE {(6, -2) (5, -2)};
//     @LINE {(0, -7) (0, -6)}
//   };
//   # @SET-SYMBOL %PA_SYMBOL;
//   $CANVAS_TYPESETTING @ATTACH(subscript_italic=false) #(level);
//   #MP1A @SET-SYMBOL(terminals=[[1, "d"], [2, "g"], [3, "s"]]) $NMOS => @PLACE(0, -16) => @ORIENT("R0");
//   #MP1B @SET-SYMBOL(terminals=[[1, "d"], [2, "g"], [3, "s"]]) $NMOS => @PLACE(14, -16) => @ORIENT("MY");
//   #MP2A @SET-SYMBOL(terminals=[[1, "d"], [2, "g"], [3, "s"]]) $NMOS => @PLACE(0, -10) => @ORIENT("MY");
//   #MP2B @SET-SYMBOL(terminals=[[1, "d"], [2, "g"], [3, "s"]]) $NMOS => @PLACE(14, -10) => @ORIENT("R0");
//   #Rc @SET-SYMBOL $RESISTOR => @PLACE(7, -6) => @ORIENT("R0");
//   #LBWc @SET-SYMBOL $INDUCTOR => @PLACE(7, 0) => @ORIENT("R0");
//   #Cf1 @SET-SYMBOL $CAPACITOR => @PLACE(-4, -9) => @ORIENT("R0");
//   #Rf1 @SET-SYMBOL $RESISTOR => @PLACE(-4, -14) => @ORIENT("R0");
//   #Cf2 @SET-SYMBOL $CAPACITOR => @PLACE(18, -9) => @ORIENT("R0");
//   #Rf2 @SET-SYMBOL $RESISTOR => @PLACE(18, -14) => @ORIENT("R0");
//   #LBWg @SET-SYMBOL $INDUCTOR => @PLACE(7, -24) => @ORIENT("R0");
//   #LBWa @SET-SYMBOL $INDUCTOR => @PLACE(0, 1) => @ORIENT("R0");
//   #LBWb @SET-SYMBOL $INDUCTOR => @PLACE(14, 1) => @ORIENT("R0");
//   $SUPPLY @ATTACH &VDD(p) => @SET-SYMBOL $SUPPLY_SYMBOL => @PLACE(0, 3) => @ORIENT("R0") => %vdd1;
//   $SUPPLY @ATTACH &VDD(p) => @SET-SYMBOL $SUPPLY_SYMBOL => @PLACE(14, 3) => @ORIENT("R0") => %vdd2;
//   $IO_PORT @ATTACH &VB(p) => @SET-SYMBOL $IO_PORT_SYMBOL => @PLACE(7, 4) => @ORIENT("R270") => %port1;
//   $IO_PORT @ATTACH &inp(p) => @SET-SYMBOL $IO_PORT_SYMBOL => @PLACE(-9, -16) => @ORIENT("R0") => %port2;
//   $IO_PORT @ATTACH &inn(p) => @SET-SYMBOL $IO_PORT_SYMBOL => @PLACE(23, -16) => @ORIENT("MY") => %port3;
//   $IO_PORT @ATTACH &outp(p) => @SET-SYMBOL $IO_PORT_SYMBOL => @PLACE(-9, -2) => @ORIENT("R0") => %port4;
//   $IO_PORT @ATTACH &outn(p) => @SET-SYMBOL $IO_PORT_SYMBOL => @PLACE(23, -2) => @ORIENT("MY") => %port5;
//   $IO_PORT @ATTACH &src(p) => @SET-SYMBOL $IO_PORT_SYMBOL => @PLACE(23, -20) => @ORIENT("MY") => %port6;
//   $GROUND @ATTACH &VSS(p) => @SET-SYMBOL $GROUND_SYMBOL => @PLACE(7, -26) => @ORIENT("R0") => %gnd1;
//   %j1 = (7, -10);
//   %j2 = (0, -6);
//   %j3 = (14, -6);
//   %j4 = (7, -20);
//   %j5 = (14, -20);
//   %j6 = (0, -2);
//   %j7 = (14, -2);
//   &outp @WIRE(mode="straight") {%port4::pin %j6};
//   &outp @WIRE(mode="straight") {%j6 %j2};
//   &outp @WIRE(mode="straight") {%j2 #MP2A:1};
//   &outn @WIRE(mode="straight") {%port5::pin %j7};
//   &outn @WIRE(mode="straight") {%j7 %j3};
//   &outn @WIRE(mode="straight") {%j3 #MP2B:1};
//   &net0 @WIRE(mode="straight") {#MP2A:3 #MP1A:1};
//   &net2 @WIRE(mode="straight") {#MP2B:3 #MP1B:1};
//   &net4 @WIRE(mode="straight") {#MP2A:2 %j1};
//   &net4 @WIRE(mode="straight") {%j1 #MP2B:2};
//   &net4 @WIRE(mode="straight") {#Rc:2 %j1};
//   &net5 @WIRE(mode="straight") {#Rc:1 #LBWc:2};
//   &VB @WIRE(mode="straight") {#LBWc:1 %port1::pin};
//   &outp @WIRE(mode="straight") {#Cf1:1 (-4, -6) %j2};
//   &net3 @WIRE(mode="straight") {#Cf1:2 #Rf1:1};
//   &inp @WIRE(mode="straight") {%port2::pin #Rf1:2};
//   &inp @WIRE(mode="straight") {#Rf1:2 #MP1A:2};
//   &outn @WIRE(mode="straight") {#Cf2:1 (18, -6) %j3};
//   &net1 @WIRE(mode="straight") {#Cf2:2 #Rf2:1};
//   &inn @WIRE(mode="straight") {%port3::pin #Rf2:2};
//   &inn @WIRE(mode="straight") {#Rf2:2 #MP1B:2};
//   &src @WIRE(mode="straight") {#MP1A:3 (0, -20) %j4};
//   &src @WIRE(mode="straight") {%j4 %j5};
//   &src @WIRE(mode="straight") {%j5 #MP1B:3};
//   &src @WIRE(mode="straight") {%j4 #LBWg:1};
//   &src @WIRE(mode="straight") {%port6::pin %j5};
//   &outp @WIRE(mode="straight") {#LBWa:2 %j6};
//   &outn @WIRE(mode="straight") {#LBWb:2 %j7};
//   &VDD @WIRE(mode="straight") {#LBWb:1 %vdd2::pin};
//   &VDD @WIRE(mode="straight") {#LBWa:1 %vdd1::pin};
//   $JUNCTION @ATTACH (18, -16)(p) => @PLACE(18, -16) => %dot1;
//   $JUNCTION @ATTACH %j6(p) => @PLACE(0, -2) => %dot2;
//   $JUNCTION @ATTACH %j2(p) => @PLACE(0, -6) => %dot3;
//   $JUNCTION @ATTACH %j7(p) => @PLACE(14, -2) => %dot4;
//   $JUNCTION @ATTACH %j3(p) => @PLACE(14, -6) => %dot5;
//   $JUNCTION @ATTACH (-4, -16)(p) => @PLACE(-4, -16) => %dot6;
//   $JUNCTION @ATTACH %j4(p) => @PLACE(7, -20) => %dot7;
//   $JUNCTION @ATTACH %j5(p) => @PLACE(14, -20) => %dot8;
//   &VSS @WIRE(mode="straight") {%gnd1::pin #LBWg:2};
//   $JUNCTION @ATTACH %j1(p) => @PLACE(7, -10) => %dot9;
//   #MP1A
//       @TEXT("\textbf{\textit{M}}_{\textbf{P1A}}", key="name", dx=0.5, dy=-0.5, halign="start", valign="baseline", size=1.5116,
//       bold=false, textvisible=true);
//   $CANVAS_LABEL @ATTACH(bind="name") #MP1A::name(label);
//   #MP1B
//       @TEXT("\textbf{\textit{M}}_{\textbf{P1B}}", key="name", dx=-0.5, dy=-0.5, halign="end", valign="baseline", size=1.5116,
//       bold=false, textvisible=true);
//   $CANVAS_LABEL @ATTACH(bind="name") #MP1B::name(label);
//   #MP2A
//       @TEXT("\textbf{\textit{M}}_{\textbf{P2A}}", key="name", dx=3.4, dy=-1.8, halign="start", valign="baseline", size=1.5116,
//       bold=false, textvisible=true);
//   $CANVAS_LABEL @ATTACH(bind="name") #MP2A::name(label);
//   #MP2B
//       @TEXT("\textbf{\textit{M}}_{\textbf{P2B}}", key="name", dx=-2.2, dy=-3.5, halign="middle", valign="baseline", size=1.5116,
//       bold=false, textvisible=true);
//   $CANVAS_LABEL @ATTACH(bind="name") #MP2B::name(label);
//   #Rc
//       @TEXT("\textbf{\textit{R}}_{\textbf{c}}", key="name", dx=0.9, dy=-0.5, halign="start", valign="baseline", size=1.5116,
//       bold=false, textvisible=true);
//   $CANVAS_LABEL @ATTACH(bind="name") #Rc::name(label);
//   #LBWc
//       @TEXT("\textbf{\textit{L}}_{\textbf{BWc}}", key="name", dx=1.2, dy=-0.5, halign="start", valign="baseline", size=1.5116,
//       bold=false, textvisible=true);
//   $CANVAS_LABEL @ATTACH(bind="name") #LBWc::name(label);
//   #Cf1
//       @TEXT("\textbf{\textit{C}}_{\textbf{f1}}", key="name", dx=-1.2, dy=-0.5, halign="end", valign="baseline", size=1.5116,
//       bold=false, textvisible=true);
//   $CANVAS_LABEL @ATTACH(bind="name") #Cf1::name(label);
//   #Rf1
//       @TEXT("\textbf{\textit{R}}_{\textbf{f1}}", key="name", dx=-0.9, dy=-0.5, halign="end", valign="baseline", size=1.5116,
//       bold=false, textvisible=true);
//   $CANVAS_LABEL @ATTACH(bind="name") #Rf1::name(label);
//   #Cf2
//       @TEXT("\textbf{\textit{C}}_{\textbf{f2}}", key="name", dx=1.2, dy=-0.5, halign="start", valign="baseline", size=1.5116,
//       bold=false, textvisible=true);
//   $CANVAS_LABEL @ATTACH(bind="name") #Cf2::name(label);
//   #Rf2
//       @TEXT("\textbf{\textit{R}}_{\textbf{f2}}", key="name", dx=0.9, dy=-0.5, halign="start", valign="baseline", size=1.5116,
//       bold=false, textvisible=true);
//   $CANVAS_LABEL @ATTACH(bind="name") #Rf2::name(label);
//   #LBWg
//       @TEXT("\textbf{\textit{L}}_{\textbf{BWg}}", key="name", dx=1.2, dy=-0.5, halign="start", valign="baseline", size=1.5116,
//       bold=false, textvisible=true);
//   $CANVAS_LABEL @ATTACH(bind="name") #LBWg::name(label);
//   #LBWa
//       @TEXT("\textbf{\textit{L}}_{\textbf{BWa}}", key="name", dx=1.2, dy=-0.5, halign="start", valign="baseline", size=1.5116,
//       bold=false, textvisible=true);
//   $CANVAS_LABEL @ATTACH(bind="name") #LBWa::name(label);
//   #LBWb
//       @TEXT("\textbf{\textit{L}}_{\textbf{BWb}}", key="name", dx=1.2, dy=-0.5, halign="start", valign="baseline", size=1.5116,
//       bold=false, textvisible=true);
//   $CANVAS_LABEL @ATTACH(bind="name") #LBWb::name(label);
//   %vdd1 @TEXT("\textbf{\textit{V}}_{\textbf{DD}}", dx=2, dy=1, size=1.5116, bold=false) => %power1;
//   $CANVAS_LABEL @ATTACH(bind="port") %power1(label);
//   %vdd2 @TEXT("\textbf{\textit{V}}_{\textbf{DD}}", dx=2, dy=1, size=1.5116, bold=false) => %power2;
//   $CANVAS_LABEL @ATTACH(bind="port") %power2(label);
//   %port1
//       @TEXT("\textbf{\textit{V}}_{\textbf{B}}", key="netname", dx=0, dy=1.9, halign="middle", valign="baseline", size=1.5116,
//       bold=false, textvisible=true);
//   $CANVAS_LABEL @ATTACH(bind="port") %port1::netname(label);
//   %port2
//       @TEXT("\textbf{\textit{inp}}", key="netname", dx=-2, dy=-0.5, halign="end", valign="baseline", size=1.5116, bold=false,
//       textvisible=true);
//   $CANVAS_LABEL @ATTACH(bind="port") %port2::netname(label);
//   %port3
//       @TEXT("\textbf{\textit{inn}}", key="netname", dx=2, dy=-0.5, halign="start", valign="baseline", size=1.5116, bold=false,
//       textvisible=true);
//   $CANVAS_LABEL @ATTACH(bind="port") %port3::netname(label);
//   %port4
//       @TEXT("\textbf{\textit{outp}}", key="netname", dx=-2, dy=-0.5, halign="end", valign="baseline", size=1.5116, bold=false,
//       textvisible=true);
//   $CANVAS_LABEL @ATTACH(bind="port") %port4::netname(label);
//   %port5
//       @TEXT("\textbf{\textit{outn}}", key="netname", dx=2, dy=-0.5, halign="start", valign="baseline", size=1.5116, bold=false,
//       textvisible=true);
//   $CANVAS_LABEL @ATTACH(bind="port") %port5::netname(label);
//   %port6
//       @TEXT("\textbf{\textit{src}}", key="netname", dx=2, dy=-0.5, halign="start", valign="baseline", size=1.5116, bold=false,
//       textvisible=true);
//   $CANVAS_LABEL @ATTACH(bind="port") %port6::netname(label);
//   %vdd1 @TEXT("${p}", key="netname", textvisible=false);
//   %vdd2 @TEXT("${p}", key="netname", textvisible=false)
// }
ends PA

subckt DA (VSS VB inp inn outp outn src)
Cf1 (outp net0) capacitor c=1p
Cf2 (outn net4) capacitor c=1p
LBWc (VB net1) inductor l=1n
LBWg (src VSS) inductor l=1n
MD1A (net2 inp src VSS) sky130_fd_pr__nfet_01v8 l=0.15 w=1 nf=1 m=1
MD1B (net5 inn src VSS) sky130_fd_pr__nfet_01v8 l=0.15 w=1 nf=1 m=1
MD2A (outp net3 net2 VSS) sky130_fd_pr__nfet_01v8 l=0.15 w=1 nf=1 m=1
MD2B (outn net3 net5 VSS) sky130_fd_pr__nfet_01v8 l=0.15 w=1 nf=1 m=1
Rc (net1 net3) resistor r=1k
Rf1 (net0 inp) resistor r=1k
Rf2 (net4 inn) resistor r=1k
// @RNL(author="analog-canvas") {
//   %DA_SYMBOL = @DEFINE-SYMBOL(box=[-6, -7, 6, 7]) {
//     (0, 7) @PIN(terminal="VB", label="\textbf{\textit{V}}_{\textbf{B}}", direction="up");
//     (-6, 2) @PIN(terminal="inp", label="\textbf{\textit{inp}}", direction="left");
//     (-6, -2) @PIN(terminal="inn", label="\textbf{\textit{inn}}", direction="left");
//     (6, 2) @PIN(terminal="outp", label="\textbf{\textit{outp}}", direction="right");
//     (6, -2) @PIN(terminal="outn", label="\textbf{\textit{outn}}", direction="right");
//     (0, -7) @PIN(terminal="src", label="\textbf{\textit{src}}", direction="down");
//     (0, 0) @RECTANGLE(width=10, height=12);
//     @LINE {(0, 7) (0, 6)};
//     @LINE {(-6, 2) (-5, 2)};
//     @LINE {(-6, -2) (-5, -2)};
//     @LINE {(6, 2) (5, 2)};
//     @LINE {(6, -2) (5, -2)};
//     @LINE {(0, -7) (0, -6)}
//   };
//   # @SET-SYMBOL %DA_SYMBOL;
//   $CANVAS_TYPESETTING @ATTACH(subscript_italic=false) #(level);
//   #MD1A @SET-SYMBOL(terminals=[[1, "d"], [2, "g"], [3, "s"]]) $NMOS => @PLACE(0, -16) => @ORIENT("R0");
//   #MD1B @SET-SYMBOL(terminals=[[1, "d"], [2, "g"], [3, "s"]]) $NMOS => @PLACE(14, -16) => @ORIENT("MY");
//   #MD2A @SET-SYMBOL(terminals=[[1, "d"], [2, "g"], [3, "s"]]) $NMOS => @PLACE(0, -10) => @ORIENT("MY");
//   #MD2B @SET-SYMBOL(terminals=[[1, "d"], [2, "g"], [3, "s"]]) $NMOS => @PLACE(14, -10) => @ORIENT("R0");
//   #Rc @SET-SYMBOL $RESISTOR => @PLACE(7, -6) => @ORIENT("R0");
//   #LBWc @SET-SYMBOL $INDUCTOR => @PLACE(7, 0) => @ORIENT("R0");
//   #Cf1 @SET-SYMBOL $CAPACITOR => @PLACE(-4, -9) => @ORIENT("R0");
//   #Rf1 @SET-SYMBOL $RESISTOR => @PLACE(-4, -14) => @ORIENT("R0");
//   #Cf2 @SET-SYMBOL $CAPACITOR => @PLACE(18, -9) => @ORIENT("R0");
//   #Rf2 @SET-SYMBOL $RESISTOR => @PLACE(18, -14) => @ORIENT("R0");
//   #LBWg @SET-SYMBOL $INDUCTOR => @PLACE(7, -24) => @ORIENT("R0");
//   $IO_PORT @ATTACH &VB(p) => @SET-SYMBOL $IO_PORT_SYMBOL => @PLACE(7, 4) => @ORIENT("R270") => %port1;
//   $IO_PORT @ATTACH &inp(p) => @SET-SYMBOL $IO_PORT_SYMBOL => @PLACE(-9, -16) => @ORIENT("R0") => %port2;
//   $IO_PORT @ATTACH &inn(p) => @SET-SYMBOL $IO_PORT_SYMBOL => @PLACE(23, -16) => @ORIENT("MY") => %port3;
//   $IO_PORT @ATTACH &outp(p) => @SET-SYMBOL $IO_PORT_SYMBOL => @PLACE(-9, -2) => @ORIENT("R0") => %port4;
//   $IO_PORT @ATTACH &outn(p) => @SET-SYMBOL $IO_PORT_SYMBOL => @PLACE(23, -2) => @ORIENT("MY") => %port5;
//   $IO_PORT @ATTACH &src(p) => @SET-SYMBOL $IO_PORT_SYMBOL => @PLACE(23, -20) => @ORIENT("MY") => %port6;
//   $GROUND @ATTACH &VSS(p) => @SET-SYMBOL $GROUND_SYMBOL => @PLACE(7, -26) => @ORIENT("R0") => %gnd1;
//   %j1 = (7, -10);
//   %j2 = (0, -6);
//   %j3 = (14, -6);
//   %j4 = (7, -20);
//   %j5 = (14, -20);
//   &outp @WIRE(mode="straight") {%port4::pin (0, -2) %j2};
//   &outp @WIRE(mode="straight") {%j2 #MD2A:1};
//   &outn @WIRE(mode="straight") {%port5::pin (14, -2) %j3};
//   &outn @WIRE(mode="straight") {%j3 #MD2B:1};
//   &net2 @WIRE(mode="straight") {#MD2A:3 #MD1A:1};
//   &net5 @WIRE(mode="straight") {#MD2B:3 #MD1B:1};
//   &net3 @WIRE(mode="straight") {#MD2A:2 %j1};
//   &net3 @WIRE(mode="straight") {%j1 #MD2B:2};
//   &net3 @WIRE(mode="straight") {#Rc:2 %j1};
//   &net1 @WIRE(mode="straight") {#Rc:1 #LBWc:2};
//   &VB @WIRE(mode="straight") {#LBWc:1 %port1::pin};
//   &outp @WIRE(mode="straight") {#Cf1:1 (-4, -6) %j2};
//   &net0 @WIRE(mode="straight") {#Cf1:2 #Rf1:1};
//   &inp @WIRE(mode="straight") {%port2::pin #Rf1:2};
//   &inp @WIRE(mode="straight") {#Rf1:2 #MD1A:2};
//   &outn @WIRE(mode="straight") {#Cf2:1 (18, -6) %j3};
//   &net4 @WIRE(mode="straight") {#Cf2:2 #Rf2:1};
//   &inn @WIRE(mode="straight") {%port3::pin #Rf2:2};
//   &inn @WIRE(mode="straight") {#Rf2:2 #MD1B:2};
//   &src @WIRE(mode="straight") {#MD1A:3 (0, -20) %j4};
//   &src @WIRE(mode="straight") {%j4 %j5};
//   &src @WIRE(mode="straight") {%j5 #MD1B:3};
//   &src @WIRE(mode="straight") {%j4 #LBWg:1};
//   &src @WIRE(mode="straight") {%port6::pin %j5};
//   $JUNCTION @ATTACH %j3(p) => @PLACE(14, -6) => %dot1;
//   $JUNCTION @ATTACH (18, -16)(p) => @PLACE(18, -16) => %dot2;
//   $JUNCTION @ATTACH %j4(p) => @PLACE(7, -20) => %dot3;
//   $JUNCTION @ATTACH %j5(p) => @PLACE(14, -20) => %dot4;
//   $JUNCTION @ATTACH %j2(p) => @PLACE(0, -6) => %dot5;
//   $JUNCTION @ATTACH (-4, -16)(p) => @PLACE(-4, -16) => %dot6;
//   &VSS @WIRE(mode="straight") {%gnd1::pin #LBWg:2};
//   $JUNCTION @ATTACH %j1(p) => @PLACE(7, -10) => %dot7;
//   #MD1A
//       @TEXT("\textbf{\textit{M}}_{\textbf{D1A}}", key="name", dx=0.5, dy=-0.5, halign="start", valign="baseline", size=1.5116,
//       bold=false, textvisible=true);
//   $CANVAS_LABEL @ATTACH(bind="name") #MD1A::name(label);
//   #MD1B
//       @TEXT("\textbf{\textit{M}}_{\textbf{D1B}}", key="name", dx=-0.5, dy=-0.5, halign="end", valign="baseline", size=1.5116,
//       bold=false, textvisible=true);
//   $CANVAS_LABEL @ATTACH(bind="name") #MD1B::name(label);
//   #MD2A
//       @TEXT("\textbf{\textit{M}}_{\textbf{D2A}}", key="name", dx=3.4, dy=-1.8, halign="start", valign="baseline", size=1.5116,
//       bold=false, textvisible=true);
//   $CANVAS_LABEL @ATTACH(bind="name") #MD2A::name(label);
//   #MD2B
//       @TEXT("\textbf{\textit{M}}_{\textbf{D2B}}", key="name", dx=-2.2, dy=-3.5, halign="middle", valign="baseline", size=1.5116,
//       bold=false, textvisible=true);
//   $CANVAS_LABEL @ATTACH(bind="name") #MD2B::name(label);
//   #Rc
//       @TEXT("\textbf{\textit{R}}_{\textbf{c}}", key="name", dx=0.9, dy=-0.5, halign="start", valign="baseline", size=1.5116,
//       bold=false, textvisible=true);
//   $CANVAS_LABEL @ATTACH(bind="name") #Rc::name(label);
//   #LBWc
//       @TEXT("\textbf{\textit{L}}_{\textbf{BWc}}", key="name", dx=1.2, dy=-0.5, halign="start", valign="baseline", size=1.5116,
//       bold=false, textvisible=true);
//   $CANVAS_LABEL @ATTACH(bind="name") #LBWc::name(label);
//   #Cf1
//       @TEXT("\textbf{\textit{C}}_{\textbf{f1}}", key="name", dx=-1.2, dy=-0.5, halign="end", valign="baseline", size=1.5116,
//       bold=false, textvisible=true);
//   $CANVAS_LABEL @ATTACH(bind="name") #Cf1::name(label);
//   #Rf1
//       @TEXT("\textbf{\textit{R}}_{\textbf{f1}}", key="name", dx=-0.9, dy=-0.5, halign="end", valign="baseline", size=1.5116,
//       bold=false, textvisible=true);
//   $CANVAS_LABEL @ATTACH(bind="name") #Rf1::name(label);
//   #Cf2
//       @TEXT("\textbf{\textit{C}}_{\textbf{f2}}", key="name", dx=1.2, dy=-0.5, halign="start", valign="baseline", size=1.5116,
//       bold=false, textvisible=true);
//   $CANVAS_LABEL @ATTACH(bind="name") #Cf2::name(label);
//   #Rf2
//       @TEXT("\textbf{\textit{R}}_{\textbf{f2}}", key="name", dx=0.9, dy=-0.5, halign="start", valign="baseline", size=1.5116,
//       bold=false, textvisible=true);
//   $CANVAS_LABEL @ATTACH(bind="name") #Rf2::name(label);
//   #LBWg
//       @TEXT("\textbf{\textit{L}}_{\textbf{BWg}}", key="name", dx=1.2, dy=-0.5, halign="start", valign="baseline", size=1.5116,
//       bold=false, textvisible=true);
//   $CANVAS_LABEL @ATTACH(bind="name") #LBWg::name(label);
//   %port1
//       @TEXT("\textbf{\textit{V}}_{\textbf{B}}", key="netname", dx=0, dy=1.9, halign="middle", valign="baseline", size=1.5116,
//       bold=false, textvisible=true);
//   $CANVAS_LABEL @ATTACH(bind="port") %port1::netname(label);
//   %port2
//       @TEXT("\textbf{\textit{inp}}", key="netname", dx=-2, dy=-0.5, halign="end", valign="baseline", size=1.5116, bold=false,
//       textvisible=true);
//   $CANVAS_LABEL @ATTACH(bind="port") %port2::netname(label);
//   %port3
//       @TEXT("\textbf{\textit{inn}}", key="netname", dx=2, dy=-0.5, halign="start", valign="baseline", size=1.5116, bold=false,
//       textvisible=true);
//   $CANVAS_LABEL @ATTACH(bind="port") %port3::netname(label);
//   %port4
//       @TEXT("\textbf{\textit{outp}}", key="netname", dx=-2, dy=-0.5, halign="end", valign="baseline", size=1.5116, bold=false,
//       textvisible=true);
//   $CANVAS_LABEL @ATTACH(bind="port") %port4::netname(label);
//   %port5
//       @TEXT("\textbf{\textit{outn}}", key="netname", dx=2, dy=-0.5, halign="start", valign="baseline", size=1.5116, bold=false,
//       textvisible=true);
//   $CANVAS_LABEL @ATTACH(bind="port") %port5::netname(label);
//   %port6
//       @TEXT("\textbf{\textit{src}}", key="netname", dx=2, dy=-0.5, halign="start", valign="baseline", size=1.5116, bold=false,
//       textvisible=true);
//   $CANVAS_LABEL @ATTACH(bind="port") %port6::netname(label)
// }
ends DA

subckt dut (VDD VSS RFIN RFOUT V_bias VB_DA VB_PA VB_PA2)
C1 (net9 net8) capacitor c=1p
Cblk1 (net13 net10) capacitor c=1p
Cblk2 (net24 net22) capacitor c=1p
Cblk3 (net9 net14) capacitor c=1p
Cblk4 (net8 net19) capacitor c=1p
Cblk5 (net6 net9) capacitor c=1p
Cblk6 (net0 net8) capacitor c=1p
Cbyp1 (net11 net21) capacitor c=1p
Cbyp2 (net7 net18) capacitor c=1p
CIN1 (net16 net23) capacitor c=1p
CIN2 (net13 net24) capacitor c=1p
Cout1a (net20 net25) capacitor c=1p
Cout1b (net4 net2) capacitor c=1p
Cout2 (net3 net12) capacitor c=1p
Lb1 (net16 net5) inductor l=1n
Lb2 (net5 net23) inductor l=1n
Lb3 (net13 VSS) inductor l=1n
Lb4 (VSS net24) inductor l=1n
LBW1 (RFIN net16) inductor l=1n
LBW2 (VSS net23) inductor l=1n
LBW3 (net1 V_bias) inductor l=1n
LBW4 (net21 VDD) inductor l=1n
LBW5 (V_bias net15) inductor l=1n
LBW6 (net17 V_bias) inductor l=1n
LBW7 (net12 RFOUT) inductor l=1n
LBW8 (net3 VSS) inductor l=1n
Lp1a (net20 net18) inductor l=1n
Lp1b (net18 net25) inductor l=1n
Lp2 (net4 net2) inductor l=1n
Ls (net12 net3) inductor l=1n
R1 (net1 net10) resistor r=1k
R2 (net1 net22) resistor r=1k
R3 (net14 net15) resistor r=1k
R4 (net19 net15) resistor r=1k
R5 (net6 net17) resistor r=1k
R6 (net0 net17) resistor r=1k
X1 (VSS VB_DA net10 net22 net9 net8 net11) DA
X2 (VDD VSS VB_PA net14 net19 net20 net25 net7) PA
X3 (VDD VSS VB_PA2 net6 net0 net4 net2 NC0001) PA
XL1 (net9 net8 net21) ct_inductor l1=1n l2=1n k=0
TF1 mutual_inductor coupling=1 ind1=Lb1 ind2=Lb3
TF2 mutual_inductor coupling=1 ind1=Lb2 ind2=Lb4
TF3 mutual_inductor coupling=1 ind1=Lp1a ind2=Ls
TF4 mutual_inductor coupling=1 ind1=Lp1b ind2=Ls
TF5 mutual_inductor coupling=1 ind1=Lp2 ind2=Ls
// @RNL(author="analog-canvas") {
//   %dut_SYMBOL = @DEFINE-SYMBOL(box=[-8, -8, 8, 8]) {
//     (-8, 0) @PIN(terminal="RFIN", label="\textbf{\textit{RFIN}}", direction="left");
//     (8, -5) @PIN(terminal="RFOUT", label="\textbf{\textit{RFOUT}}", direction="right");
//     (8, 3) @PIN(terminal="V_bias", label="\textbf{\textit{V}}_{\textbf{\textit{bias}}}", direction="right");
//     (8, 1) @PIN(terminal="VB_DA", label="\textbf{\textit{VB}}_{\textbf{\textit{DA}}}", direction="right");
//     (-8, -2) @PIN(terminal="VB_PA", label="\textbf{\textit{VB}}_{\textbf{\textit{PA}}}", direction="left");
//     (8, -3) @PIN(terminal="VB_PA2", label="\textbf{\textit{VB}}_{\textbf{\textit{PA2}}}", direction="right");
//     (8, -1) @PIN(terminal="VDD", label="\textbf{\textit{V}}_{\textbf{DD}}", direction="right");
//     (0, 0) @RECTANGLE(width=14, height=14);
//     @LINE {(-8, 0) (-7, 0)};
//     @LINE {(8, -5) (7, -5)};
//     @LINE {(8, 3) (7, 3)};
//     @LINE {(8, 1) (7, 1)};
//     @LINE {(-8, -2) (-7, -2)};
//     @LINE {(8, -3) (7, -3)};
//     @LINE {(8, -1) (7, -1)}
//   };
//   # @SET-SYMBOL %dut_SYMBOL;
//   $CANVAS_TYPESETTING @ATTACH(subscript_italic=false) #(level);
//   #X1 @PLACE(40, -5) => @ORIENT("R0");
//   #X2 @PLACE(15, -29) => @ORIENT("R0");
//   #X3 @PLACE(52, -29) => @ORIENT("MY");
//   #LBW1 @SET-SYMBOL $INDUCTOR => @PLACE(2, 1) => @ORIENT("R90");
//   #CIN1 @SET-SYMBOL $CAPACITOR => @PLACE(6, -5) => @ORIENT("R0");
//   #Lb1 @SET-SYMBOL $INDUCTOR => @PLACE(10, -2) => @ORIENT("R0");
//   #Lb2 @SET-SYMBOL $INDUCTOR => @PLACE(10, -9) => @ORIENT("R0");
//   #LBW2 @SET-SYMBOL $INDUCTOR => @PLACE(2, -12) => @ORIENT("R90");
//   #Lb3 @SET-SYMBOL $INDUCTOR => @PLACE(14, -2) => @ORIENT("R0");
//   #Lb4 @SET-SYMBOL $INDUCTOR => @PLACE(14, -9) => @ORIENT("R0");
//   #CIN2 @SET-SYMBOL $CAPACITOR => @PLACE(20, -5) => @ORIENT("R0");
//   #Cblk1 @SET-SYMBOL $CAPACITOR => @PLACE(23, 1) => @ORIENT("R90");
//   #Cblk2 @SET-SYMBOL $CAPACITOR => @PLACE(23, -12) => @ORIENT("R90");
//   #R1 @SET-SYMBOL $RESISTOR => @PLACE(27, 4) => @ORIENT("R0");
//   #R2 @SET-SYMBOL $RESISTOR => @PLACE(30, 4) => @ORIENT("R0");
//   #LBW3 @SET-SYMBOL $INDUCTOR => @PLACE(33, 7) => @ORIENT("R90");
//   #C1 @SET-SYMBOL $VARIABLE_CAPACITOR => @PLACE(48, -5) => @ORIENT("R0");
//   #XL1 @SET-SYMBOL(terminals=[[1, "n1"], [2, "n2"], [3, "tap"]]) $CENTER_TAP_INDUCTOR => @PLACE(52, -5) => @ORIENT("MYR90");
//   #LBW4 @SET-SYMBOL $INDUCTOR => @PLACE(58, -5) => @ORIENT("R90");
//   #Cbyp1 @SET-SYMBOL $CAPACITOR => @PLACE(45, -14) => @ORIENT("R90");
//   #Cblk3 @SET-SYMBOL $CAPACITOR => @PLACE(2, -27) => @ORIENT("R90");
//   #Cblk4 @SET-SYMBOL $CAPACITOR => @PLACE(2, -31) => @ORIENT("R90");
//   #R3 @SET-SYMBOL $RESISTOR => @PLACE(5, -35) => @ORIENT("R0");
//   #R4 @SET-SYMBOL $RESISTOR => @PLACE(7, -35) => @ORIENT("R0");
//   #LBW5 @SET-SYMBOL $INDUCTOR => @PLACE(1, -38) => @ORIENT("R90");
//   #Cout1a @SET-SYMBOL $VARIABLE_CAPACITOR => @PLACE(23, -29) => @ORIENT("R0");
//   #Lp1a @SET-SYMBOL $INDUCTOR => @PLACE(27, -26) => @ORIENT("R0");
//   #Lp1b @SET-SYMBOL $INDUCTOR => @PLACE(27, -32) => @ORIENT("R0");
//   #Cbyp2 @SET-SYMBOL $CAPACITOR => @PLACE(21, -38) => @ORIENT("R90");
//   #Ls @SET-SYMBOL $INDUCTOR => @PLACE(31, -29) => @ORIENT("MX");
//   #Cout2 @SET-SYMBOL $CAPACITOR => @PLACE(34, -29) => @ORIENT("R0");
//   #LBW8 @SET-SYMBOL $INDUCTOR => @PLACE(37, -29) => @ORIENT("R0");
//   #LBW7 @SET-SYMBOL $INDUCTOR => @PLACE(31, -35) => @ORIENT("R0");
//   #Lp2 @SET-SYMBOL $INDUCTOR => @PLACE(40, -29) => @ORIENT("R0");
//   #Cout1b @SET-SYMBOL $VARIABLE_CAPACITOR => @PLACE(44, -29) => @ORIENT("R0");
//   #Cblk5 @SET-SYMBOL $CAPACITOR => @PLACE(65, -27) => @ORIENT("R90");
//   #Cblk6 @SET-SYMBOL $CAPACITOR => @PLACE(65, -31) => @ORIENT("R90");
//   #R5 @SET-SYMBOL $RESISTOR => @PLACE(62, -35) => @ORIENT("R0");
//   #R6 @SET-SYMBOL $RESISTOR => @PLACE(60, -35) => @ORIENT("R0");
//   #LBW6 @SET-SYMBOL $INDUCTOR => @PLACE(66, -38) => @ORIENT("R90");
//   $IO_PORT @ATTACH &RFIN(p) => @SET-SYMBOL $IO_PORT_SYMBOL => @PLACE(-3, 1) => @ORIENT("R0") => %port1;
//   $IO_PORT @ATTACH &RFOUT(p) => @SET-SYMBOL $IO_PORT_SYMBOL => @PLACE(72, -41) => @ORIENT("MY") => %port2;
//   $IO_PORT @ATTACH &V_bias(p) => @SET-SYMBOL $IO_PORT_SYMBOL => @PLACE(37, 7) => @ORIENT("MY") => %port3;
//   $IO_PORT @ATTACH &V_bias(p) => @SET-SYMBOL $IO_PORT_SYMBOL => @PLACE(-5, -38) => @ORIENT("R0") => %port4;
//   $IO_PORT @ATTACH &V_bias(p) => @SET-SYMBOL $IO_PORT_SYMBOL => @PLACE(72, -38) => @ORIENT("MY") => %port5;
//   $IO_PORT @ATTACH &VB_DA(p) => @SET-SYMBOL $IO_PORT_SYMBOL => @PLACE(45, 4) => @ORIENT("MY") => %port6;
//   $IO_PORT @ATTACH &VB_PA(p) => @SET-SYMBOL $IO_PORT_SYMBOL => @PLACE(20, -21) => @ORIENT("MY") => %port7;
//   $IO_PORT @ATTACH &VB_PA2(p) => @SET-SYMBOL $IO_PORT_SYMBOL => @PLACE(47, -21) => @ORIENT("R0") => %port8;
//   $SUPPLY @ATTACH &VDD(p) => @SET-SYMBOL $SUPPLY_SYMBOL => @PLACE(60, -5) => @ORIENT("R270") => %vdd1;
//   $SUPPLY @ATTACH &VDD(p) => @SET-SYMBOL $SUPPLY_SYMBOL => @PLACE(13, -22) => @ORIENT("R0") => %vdd2;
//   $SUPPLY @ATTACH &VDD(p) => @SET-SYMBOL $SUPPLY_SYMBOL => @PLACE(54, -22) => @ORIENT("R0") => %vdd3;
//   $GROUND @ATTACH &VSS(p) => @SET-SYMBOL $GROUND_SYMBOL => @PLACE(0, -12) => @ORIENT("R0") => %gnd1;
//   $GROUND @ATTACH &VSS(p) => @SET-SYMBOL $GROUND_SYMBOL => @PLACE(15, -5) => @ORIENT("R90") => %gnd2;
//   $GROUND @ATTACH &VSS(p) => @SET-SYMBOL $GROUND_SYMBOL => @PLACE(37, -31) => @ORIENT("R0") => %gnd3;
//   $NO_CONNECT @ATTACH #X3:8(t) => @PLACE(52, -36);
//   %j1 = (6, 1);
//   %j2 = (6, -12);
//   %j3 = (14, -5);
//   %j4 = (20, 1);
//   %j5 = (20, -12);
//   %j6 = (27, 1);
//   %j7 = (30, -12);
//   %j8 = (30, 7);
//   %j9 = (55, -5);
//   %j10 = (52, 1);
//   %j11 = (52, -11);
//   %j12 = (65, -16);
//   %j13 = (67, -18);
//   %j14 = (5, -27);
//   %j15 = (7, -31);
//   %j16 = (5, -38);
//   %j17 = (27, -29);
//   %j18 = (34, -26);
//   %j19 = (31, -32);
//   %j20 = (62, -27);
//   %j21 = (60, -31);
//   %j22 = (62, -38);
//   &RFIN @WIRE(mode="straight") {#LBW1:1 %port1::pin};
//   &net16 @WIRE(mode="straight") {#LBW1:2 %j1};
//   &net16 @WIRE(mode="straight") {%j1 (10, 1) #Lb1:1};
//   &net16 @WIRE(mode="straight") {#CIN1:1 %j1};
//   &net5 @WIRE(mode="straight") {#Lb1:2 #Lb2:1};
//   &net23 @WIRE(mode="straight") {#Lb2:2 (10, -12) %j2};
//   &net23 @WIRE(mode="straight") {%j2 #CIN1:2};
//   &net23 @WIRE(mode="straight") {#LBW2:2 %j2};
//   &VSS @WIRE(mode="straight") {#Lb3:2 %j3};
//   &VSS @WIRE(mode="straight") {%j3 #Lb4:1};
//   &VSS @WIRE(mode="straight") {%j3 %gnd2::pin};
//   &net13 @WIRE(mode="straight") {#Lb3:1 (14, 1) %j4};
//   &net13 @WIRE(mode="straight") {%j4 #Cblk1:1};
//   &net13 @WIRE(mode="straight") {#CIN2:1 %j4};
//   &net24 @WIRE(mode="straight") {#Lb4:2 (14, -12) %j5};
//   &net24 @WIRE(mode="straight") {%j5 #Cblk2:1};
//   &net24 @WIRE(mode="straight") {#CIN2:2 %j5};
//   &net10 @WIRE(mode="straight") {#Cblk1:2 %j6};
//   &net10 @WIRE(mode="straight") {%j6 (32, 1) (32, -3) #X1:3};
//   &net22 @WIRE(mode="straight") {#Cblk2:2 %j7};
//   &net22 @WIRE(mode="straight") {%j7 (32, -12) (32, -7) #X1:4};
//   &net10 @WIRE(mode="straight") {#R1:2 %j6};
//   &net22 @WIRE(mode="straight") {#R2:2 %j7};
//   &net1 @WIRE(mode="straight") {#R1:1 (27, 7) %j8};
//   &net1 @WIRE(mode="straight") {%j8 #R2:1};
//   &net1 @WIRE(mode="straight") {#LBW3:1 %j8};
//   &V_bias @WIRE(mode="straight") {#LBW3:2 %port3::pin};
//   &VB_DA @WIRE(mode="straight") {#X1:2 (40, 4) %port6::pin};
//   &net9 @WIRE(mode="straight") {#X1:5 #C1:1};
//   &net8 @WIRE(mode="straight") {#X1:6 #C1:2};
//   &net9 @WIRE(mode="straight") {#C1:1 (48, 1) %j10};
//   &net9 @WIRE(mode="straight") {%j10 #XL1:1};
//   &net8 @WIRE(mode="straight") {#C1:2 (48, -11) %j11};
//   &net8 @WIRE(mode="straight") {%j11 #XL1:2};
//   &net21 @WIRE(mode="straight") {#XL1:3 %j9};
//   &net21 @WIRE(mode="straight") {%j9 #LBW4:1};
//   &net11 @WIRE(mode="straight") {#X1:7 (40, -14) #Cbyp1:1};
//   &net21 @WIRE(mode="straight") {#Cbyp1:2 (55, -14) %j9};
//   &net9 @WIRE(mode="straight") {#Cblk3:1 (-3, -27) (-3, -16) %j12};
//   &net9 @WIRE(mode="straight") {%j12 (65, 1) %j10};
//   &net8 @WIRE(mode="straight") {#Cblk4:1 (-1, -31) (-1, -18) %j13};
//   &net8 @WIRE(mode="straight") {%j13 (67, -11) %j11};
//   &net9 @WIRE(mode="straight") {#Cblk5:2 (71, -27) (71, -16) %j12};
//   &net8 @WIRE(mode="straight") {#Cblk6:2 (69, -31) (69, -18) %j13};
//   &net14 @WIRE(mode="straight") {#Cblk3:2 %j14};
//   &net14 @WIRE(mode="straight") {%j14 #X2:4};
//   &net19 @WIRE(mode="straight") {#Cblk4:2 %j15};
//   &net19 @WIRE(mode="straight") {%j15 #X2:5};
//   &net14 @WIRE(mode="straight") {#R3:1 %j14};
//   &net19 @WIRE(mode="straight") {#R4:1 %j15};
//   &net15 @WIRE(mode="straight") {#R3:2 %j16};
//   &net15 @WIRE(mode="straight") {%j16 (7, -38) #R4:2};
//   &net15 @WIRE(mode="straight") {#LBW5:2 %j16};
//   &V_bias @WIRE(mode="straight") {%port4::pin #LBW5:1};
//   &VB_PA @WIRE(mode="straight") {#X2:3 (17, -21) %port7::pin};
//   &net20 @WIRE(mode="straight") {#X2:6 #Cout1a:1};
//   &net25 @WIRE(mode="straight") {#X2:7 #Cout1a:2};
//   &net20 @WIRE(mode="straight") {#Cout1a:1 (23, -23) (27, -23) #Lp1a:1};
//   &net25 @WIRE(mode="straight") {#Cout1a:2 (23, -35) (27, -35) #Lp1b:2};
//   &net18 @WIRE(mode="straight") {#Lp1a:2 %j17};
//   &net18 @WIRE(mode="straight") {%j17 #Lp1b:1};
//   &net7 @WIRE(mode="straight") {#X2:8 (15, -38) #Cbyp2:1};
//   &net18 @WIRE(mode="straight") {#Cbyp2:2 (25, -38) (25, -29) %j17};
//   &net3 @WIRE(mode="straight") {#Ls:2 (31, -26) %j18};
//   &net3 @WIRE(mode="straight") {%j18 #Cout2:1};
//   &net3 @WIRE(mode="straight") {#LBW8:1 (37, -26) %j18};
//   &net12 @WIRE(mode="straight") {#Ls:1 %j19};
//   &net12 @WIRE(mode="straight") {%j19 #LBW7:1};
//   &net12 @WIRE(mode="straight") {#Cout2:2 (34, -32) %j19};
//   &RFOUT @WIRE(mode="straight") {#LBW7:2 (31, -41) %port2::pin};
//   &net4 @WIRE(mode="straight") {#X3:6 #Cout1b:1};
//   &net2 @WIRE(mode="straight") {#X3:7 #Cout1b:2};
//   &net4 @WIRE(mode="straight") {#Cout1b:1 (44, -23) (40, -23) #Lp2:1};
//   &net2 @WIRE(mode="straight") {#Cout1b:2 (44, -35) (40, -35) #Lp2:2};
//   &net6 @WIRE(mode="straight") {#Cblk5:1 %j20};
//   &net6 @WIRE(mode="straight") {%j20 #X3:4};
//   &net0 @WIRE(mode="straight") {#Cblk6:1 %j21};
//   &net0 @WIRE(mode="straight") {%j21 #X3:5};
//   &net6 @WIRE(mode="straight") {#R5:1 %j20};
//   &net0 @WIRE(mode="straight") {#R6:1 %j21};
//   &net17 @WIRE(mode="straight") {#R5:2 %j22};
//   &net17 @WIRE(mode="straight") {%j22 (60, -38) #R6:2};
//   &net17 @WIRE(mode="straight") {#LBW6:1 %j22};
//   &V_bias @WIRE(mode="straight") {%port5::pin #LBW6:2};
//   &VB_PA2 @WIRE(mode="straight") {#X3:3 (50, -21) %port8::pin};
//   &VDD @WIRE(mode="straight") {#X3:1 %vdd3::pin};
//   &VDD @WIRE(mode="straight") {#X2:1 %vdd2::pin};
//   &VDD @WIRE(mode="straight") {#LBW4:2 %vdd1::pin};
//   &VSS @WIRE(mode="straight") {%gnd1::pin #LBW2:1};
//   $JUNCTION @ATTACH %j3(p) => @PLACE(14, -5) => %dot1;
//   &VSS @WIRE(mode="straight") {%gnd3::pin #LBW8:2};
//   $JUNCTION @ATTACH %j21(p) => @PLACE(60, -31) => %dot2;
//   $JUNCTION @ATTACH %j8(p) => @PLACE(30, 7) => %dot3;
//   $JUNCTION @ATTACH (44, -31)(p) => @PLACE(44, -31) => %dot4;
//   $JUNCTION @ATTACH %j18(p) => @PLACE(34, -26) => %dot5;
//   $JUNCTION @ATTACH (44, -27)(p) => @PLACE(44, -27) => %dot6;
//   $JUNCTION @ATTACH %j20(p) => @PLACE(62, -27) => %dot7;
//   $JUNCTION @ATTACH (48, -7)(p) => @PLACE(48, -7) => %dot8;
//   $JUNCTION @ATTACH %j11(p) => @PLACE(52, -11) => %dot9;
//   $JUNCTION @ATTACH %j13(p) => @PLACE(67, -18) => %dot10;
//   $JUNCTION @ATTACH (48, -3)(p) => @PLACE(48, -3) => %dot11;
//   $JUNCTION @ATTACH %j10(p) => @PLACE(52, 1) => %dot12;
//   $JUNCTION @ATTACH %j12(p) => @PLACE(65, -16) => %dot13;
//   $JUNCTION @ATTACH %j6(p) => @PLACE(27, 1) => %dot14;
//   $JUNCTION @ATTACH %j19(p) => @PLACE(31, -32) => %dot15;
//   $JUNCTION @ATTACH %j4(p) => @PLACE(20, 1) => %dot16;
//   $JUNCTION @ATTACH %j14(p) => @PLACE(5, -27) => %dot17;
//   $JUNCTION @ATTACH %j16(p) => @PLACE(5, -38) => %dot18;
//   $JUNCTION @ATTACH %j1(p) => @PLACE(6, 1) => %dot19;
//   $JUNCTION @ATTACH %j22(p) => @PLACE(62, -38) => %dot20;
//   $JUNCTION @ATTACH %j17(p) => @PLACE(27, -29) => %dot21;
//   $JUNCTION @ATTACH %j15(p) => @PLACE(7, -31) => %dot22;
//   $JUNCTION @ATTACH (23, -27)(p) => @PLACE(23, -27) => %dot23;
//   $JUNCTION @ATTACH %j9(p) => @PLACE(55, -5) => %dot24;
//   $JUNCTION @ATTACH %j7(p) => @PLACE(30, -12) => %dot25;
//   $JUNCTION @ATTACH %j2(p) => @PLACE(6, -12) => %dot26;
//   $JUNCTION @ATTACH %j5(p) => @PLACE(20, -12) => %dot27;
//   $JUNCTION @ATTACH (23, -31)(p) => @PLACE(23, -31) => %dot28;
//   #X1
//       @TEXT("\textbf{DA}", key="value", dx=-1.4, dy=-8.5, halign="middle", valign="baseline", size=1.5116, bold=false,
//       textvisible=true);
//   #X2
//       @TEXT("\textbf{PA}", key="value", dx=-1.3, dy=-8.5, halign="middle", valign="baseline", size=1.5116, bold=false,
//       textvisible=true);
//   #X3
//       @TEXT("\textbf{PA}", key="value", dx=0, dy=-8.5, halign="middle", valign="baseline", size=1.5116, bold=false,
//       textvisible=true);
//   #LBW1
//       @TEXT("\textbf{\textit{L}}_{\textbf{BW1}}", key="name", dx=0, dy=1.7, halign="middle", valign="baseline", size=1.5116,
//       bold=false, textvisible=true);
//   $CANVAS_LABEL @ATTACH(bind="name") #LBW1::name(label);
//   #CIN1
//       @TEXT("\textbf{\textit{C}}_{\textbf{IN1}}", key="name", dx=1.2, dy=-0.5, halign="start", valign="baseline", size=1.5116,
//       bold=false, textvisible=true);
//   $CANVAS_LABEL @ATTACH(bind="name") #CIN1::name(label);
//   #Lb1
//       @TEXT("\textbf{\textit{L}}_{\textbf{b1}}", key="name", dx=-1.1, dy=-0.1, halign="end", valign="baseline", size=1.5116,
//       bold=false, textvisible=true);
//   $CANVAS_LABEL @ATTACH(bind="name") #Lb1::name(label);
//   #Lb2
//       @TEXT("\textbf{\textit{L}}_{\textbf{b2}}", key="name", dx=-1.1, dy=-0.5, halign="end", valign="baseline", size=1.5116,
//       bold=false, textvisible=true);
//   $CANVAS_LABEL @ATTACH(bind="name") #Lb2::name(label);
//   #LBW2
//       @TEXT("\textbf{\textit{L}}_{\textbf{BW2}}", key="name", dx=0, dy=1.7, halign="middle", valign="baseline", size=1.5116,
//       bold=false, textvisible=true);
//   $CANVAS_LABEL @ATTACH(bind="name") #LBW2::name(label);
//   #Lb3
//       @TEXT("\textbf{\textit{L}}_{\textbf{b3}}", key="name", dx=1.2, dy=-0.5, halign="start", valign="baseline", size=1.5116,
//       bold=false, textvisible=true);
//   $CANVAS_LABEL @ATTACH(bind="name") #Lb3::name(label);
//   #Lb4
//       @TEXT("\textbf{\textit{L}}_{\textbf{b4}}", key="name", dx=1.2, dy=-0.5, halign="start", valign="baseline", size=1.5116,
//       bold=false, textvisible=true);
//   $CANVAS_LABEL @ATTACH(bind="name") #Lb4::name(label);
//   #CIN2
//       @TEXT("\textbf{\textit{C}}_{\textbf{IN2}}", key="name", dx=1.2, dy=-0.5, halign="start", valign="baseline", size=1.5116,
//       bold=false, textvisible=true);
//   $CANVAS_LABEL @ATTACH(bind="name") #CIN2::name(label);
//   #Cblk1
//       @TEXT("\textbf{\textit{C}}_{\textbf{blk1}}", key="name", dx=0, dy=1.7, halign="middle", valign="baseline", size=1.5116,
//       bold=false, textvisible=true);
//   $CANVAS_LABEL @ATTACH(bind="name") #Cblk1::name(label);
//   #Cblk2
//       @TEXT("\textbf{\textit{C}}_{\textbf{blk2}}", key="name", dx=0, dy=1.7, halign="middle", valign="baseline", size=1.5116,
//       bold=false, textvisible=true);
//   $CANVAS_LABEL @ATTACH(bind="name") #Cblk2::name(label);
//   #R1
//       @TEXT("\textbf{\textit{R}}_{\textbf{1}}", key="name", dx=-0.9, dy=0.6, halign="end", valign="baseline", size=1.5116,
//       bold=false, textvisible=true);
//   $CANVAS_LABEL @ATTACH(bind="name") #R1::name(label);
//   #R2
//       @TEXT("\textbf{\textit{R}}_{\textbf{2}}", key="name", dx=0.9, dy=-0.5, halign="start", valign="baseline", size=1.5116,
//       bold=false, textvisible=true);
//   $CANVAS_LABEL @ATTACH(bind="name") #R2::name(label);
//   #LBW3
//       @TEXT("\textbf{\textit{L}}_{\textbf{BW3}}", key="name", dx=0, dy=1.7, halign="middle", valign="baseline", size=1.5116,
//       bold=false, textvisible=true);
//   $CANVAS_LABEL @ATTACH(bind="name") #LBW3::name(label);
//   #C1
//       @TEXT("\textbf{\textit{C}}_{\textbf{1}}", key="name", dx=1.6, dy=-0.5, halign="start", valign="baseline", size=1.5116,
//       bold=false, textvisible=true);
//   $CANVAS_LABEL @ATTACH(bind="name") #C1::name(label);
//   #XL1
//       @TEXT("\textbf{\textit{L}}_{\textbf{1}}", key="name", dx=2.8, dy=-4.4, halign="start", valign="baseline", size=1.5116,
//       bold=false, textvisible=true);
//   #LBW4
//       @TEXT("\textbf{\textit{L}}_{\textbf{BW4}}", key="name", dx=0, dy=1.7, halign="middle", valign="baseline", size=1.5116,
//       bold=false, textvisible=true);
//   $CANVAS_LABEL @ATTACH(bind="name") #LBW4::name(label);
//   #Cbyp1
//       @TEXT("\textbf{\textit{C}}_{\textbf{byp1}}", key="name", dx=3, dy=1.7, halign="middle", valign="baseline", size=1.5116,
//       bold=false, textvisible=true);
//   $CANVAS_LABEL @ATTACH(bind="name") #Cbyp1::name(label);
//   #Cblk3
//       @TEXT("\textbf{\textit{C}}_{\textbf{blk3}}", key="name", dx=0, dy=1.7, halign="middle", valign="baseline", size=1.5116,
//       bold=false, textvisible=true);
//   $CANVAS_LABEL @ATTACH(bind="name") #Cblk3::name(label);
//   #Cblk4
//       @TEXT("\textbf{\textit{C}}_{\textbf{blk4}}", key="name", dx=0, dy=1.7, halign="middle", valign="baseline", size=1.5116,
//       bold=false, textvisible=true);
//   $CANVAS_LABEL @ATTACH(bind="name") #Cblk4::name(label);
//   #R3
//       @TEXT("\textbf{\textit{R}}_{\textbf{3}}", key="name", dx=-0.9, dy=0.6, halign="end", valign="baseline", size=1.5116,
//       bold=false, textvisible=true);
//   $CANVAS_LABEL @ATTACH(bind="name") #R3::name(label);
//   #R4
//       @TEXT("\textbf{\textit{R}}_{\textbf{4}}", key="name", dx=0.9, dy=-2.4, halign="start", valign="baseline", size=1.5116,
//       bold=false, textvisible=true);
//   $CANVAS_LABEL @ATTACH(bind="name") #R4::name(label);
//   #LBW5
//       @TEXT("\textbf{\textit{L}}_{\textbf{BW5}}", key="name", dx=0, dy=1.7, halign="middle", valign="baseline", size=1.5116,
//       bold=false, textvisible=true);
//   $CANVAS_LABEL @ATTACH(bind="name") #LBW5::name(label);
//   #Cout1a
//       @TEXT("\textbf{\textit{C}}_{\textbf{out1a}}", key="name", dx=-1.6, dy=-0.5, halign="end", valign="baseline", size=1.5116,
//       bold=false, textvisible=true);
//   $CANVAS_LABEL @ATTACH(bind="name") #Cout1a::name(label);
//   #Lp1a
//       @TEXT("\textbf{\textit{L}}_{\textbf{p1a}}", key="name", dx=1.2, dy=1.8, halign="start", valign="baseline", size=1.5116,
//       bold=false, textvisible=true);
//   $CANVAS_LABEL @ATTACH(bind="name") #Lp1a::name(label);
//   #Lp1b
//       @TEXT("\textbf{\textit{L}}_{\textbf{p1b}}", key="name", dx=1.6, dy=-3.5, halign="middle", valign="baseline", size=1.5116,
//       bold=false, textvisible=true);
//   $CANVAS_LABEL @ATTACH(bind="name") #Lp1b::name(label);
//   #Cbyp2
//       @TEXT("\textbf{\textit{C}}_{\textbf{byp2}}", key="name", dx=0, dy=-2.3, halign="middle", valign="baseline", size=1.5116,
//       bold=false, textvisible=true);
//   $CANVAS_LABEL @ATTACH(bind="name") #Cbyp2::name(label);
//   #Ls
//       @TEXT("\textbf{\textit{L}}_{\textbf{s}}", key="name", dx=-1.1, dy=-0.5, halign="end", valign="baseline", size=1.5116,
//       bold=false, textvisible=true);
//   $CANVAS_LABEL @ATTACH(bind="name") #Ls::name(label);
//   #Cout2
//       @TEXT("\textbf{\textit{C}}_{\textbf{out2}}", key="name", dx=0, dy=3.7, halign="middle", valign="baseline", size=1.5116,
//       bold=false, textvisible=true);
//   $CANVAS_LABEL @ATTACH(bind="name") #Cout2::name(label);
//   #LBW8
//       @TEXT("\textbf{\textit{L}}_{\textbf{BW8}}", key="name", dx=0.8, dy=-5.3, halign="middle", valign="baseline", size=1.5116,
//       bold=false, textvisible=true);
//   $CANVAS_LABEL @ATTACH(bind="name") #LBW8::name(label);
//   #LBW7
//       @TEXT("\textbf{\textit{L}}_{\textbf{BW7}}", key="name", dx=1.2, dy=-1.2, halign="start", valign="baseline", size=1.5116,
//       bold=false, textvisible=true);
//   $CANVAS_LABEL @ATTACH(bind="name") #LBW7::name(label);
//   #Lp2
//       @TEXT("\textbf{\textit{L}}_{\textbf{p2}}", key="name", dx=1.4, dy=-3.5, halign="middle", valign="baseline", size=1.5116,
//       bold=false, textvisible=true);
//   $CANVAS_LABEL @ATTACH(bind="name") #Lp2::name(label);
//   #Cout1b
//       @TEXT("\textbf{\textit{C}}_{\textbf{out1b}}", key="name", dx=1.6, dy=-0.5, halign="start", valign="baseline", size=1.5116,
//       bold=false, textvisible=true);
//   $CANVAS_LABEL @ATTACH(bind="name") #Cout1b::name(label);
//   #Cblk5
//       @TEXT("\textbf{\textit{C}}_{\textbf{blk5}}", key="name", dx=0, dy=1.7, halign="middle", valign="baseline", size=1.5116,
//       bold=false, textvisible=true);
//   $CANVAS_LABEL @ATTACH(bind="name") #Cblk5::name(label);
//   #Cblk6
//       @TEXT("\textbf{\textit{C}}_{\textbf{blk6}}", key="name", dx=0, dy=1.7, halign="middle", valign="baseline", size=1.5116,
//       bold=false, textvisible=true);
//   $CANVAS_LABEL @ATTACH(bind="name") #Cblk6::name(label);
//   #R5
//       @TEXT("\textbf{\textit{R}}_{\textbf{5}}", key="name", dx=0.9, dy=-0.5, halign="start", valign="baseline", size=1.5116,
//       bold=false, textvisible=true);
//   $CANVAS_LABEL @ATTACH(bind="name") #R5::name(label);
//   #R6
//       @TEXT("\textbf{\textit{R}}_{\textbf{6}}", key="name", dx=-0.9, dy=-2.4, halign="end", valign="baseline", size=1.5116,
//       bold=false, textvisible=true);
//   $CANVAS_LABEL @ATTACH(bind="name") #R6::name(label);
//   #LBW6
//       @TEXT("\textbf{\textit{L}}_{\textbf{BW6}}", key="name", dx=2.4, dy=1.6, halign="start", valign="baseline", size=1.5116,
//       bold=false, textvisible=true);
//   $CANVAS_LABEL @ATTACH(bind="name") #LBW6::name(label);
//   %port1
//       @TEXT("\textbf{\textit{RFIN}}", key="netname", dx=-2, dy=-0.5, halign="end", valign="baseline", size=1.5116, bold=false,
//       textvisible=true);
//   $CANVAS_LABEL @ATTACH(bind="port") %port1::netname(label);
//   %port2
//       @TEXT("\textbf{\textit{RFOUT}}", key="netname", dx=2, dy=-0.5, halign="start", valign="baseline", size=1.5116, bold=false,
//       textvisible=true);
//   $CANVAS_LABEL @ATTACH(bind="port") %port2::netname(label);
//   %port3
//       @TEXT("\textbf{\textit{V}}_{\textbf{bias}}", key="netname", dx=2, dy=-0.5, halign="start", valign="baseline", size=1.5116,
//       bold=false, textvisible=true);
//   $CANVAS_LABEL @ATTACH(bind="port") %port3::netname(label);
//   %port4
//       @TEXT("\textbf{\textit{V}}_{\textbf{bias}}", key="netname", dx=-2, dy=-0.5, halign="end", valign="baseline", size=1.5116,
//       bold=false, textvisible=true);
//   $CANVAS_LABEL @ATTACH(bind="port") %port4::netname(label);
//   %port5
//       @TEXT("\textbf{\textit{V}}_{\textbf{bias}}", key="netname", dx=2, dy=-0.5, halign="start", valign="baseline", size=1.5116,
//       bold=false, textvisible=true);
//   $CANVAS_LABEL @ATTACH(bind="port") %port5::netname(label);
//   %port6
//       @TEXT("\textbf{\textit{VB}}_{\textbf{DA}}", key="netname", dx=2, dy=-0.5, halign="start", valign="baseline", size=1.5116,
//       bold=false, textvisible=true);
//   $CANVAS_LABEL @ATTACH(bind="port") %port6::netname(label);
//   %port7
//       @TEXT("\textbf{\textit{VB}}_{\textbf{PA}}", key="netname", dx=0.5, dy=1.2, halign="middle", valign="baseline", size=1.5116,
//       bold=false, textvisible=true);
//   $CANVAS_LABEL @ATTACH(bind="port") %port7::netname(label);
//   %port8
//       @TEXT("\textbf{\textit{VB}}_{\textbf{PA2}}", key="netname", dx=-2, dy=-0.5, halign="end", valign="baseline", size=1.5116,
//       bold=false, textvisible=true);
//   $CANVAS_LABEL @ATTACH(bind="port") %port8::netname(label);
//   %vdd1 @TEXT("\textbf{\textit{V}}_{\textbf{DD}}", dx=3, dy=0, size=1.5116, bold=false) => %power1;
//   $CANVAS_LABEL @ATTACH(bind="port") %power1(label);
//   %vdd2 @TEXT("\textbf{\textit{V}}_{\textbf{DD}}", dx=-0.8, dy=1.5, halign="end", size=1.5116, bold=false) => %power2;
//   $CANVAS_LABEL @ATTACH(bind="port") %power2(label);
//   %vdd3 @TEXT("\textbf{\textit{V}}_{\textbf{DD}}", dx=2, dy=1, size=1.5116, bold=false) => %power3;
//   $CANVAS_LABEL @ATTACH(bind="port") %power3(label);
//   %vdd1 @TEXT("${p}", key="netname", textvisible=false);
//   %vdd2 @TEXT("${p}", key="netname", textvisible=false);
//   %vdd3 @TEXT("${p}", key="netname", textvisible=false)
// }
ends dut
