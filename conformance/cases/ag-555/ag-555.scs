simulator lang=spectre
// @RNL(type="header") {
//   @VERSION("0.4");
//   @USE-PACKAGE(name="rnl-std-style", version="0.4");
//   @USE-PACKAGE(name="rnl-std-basic", version="0.4");
//   @USE-PACKAGE(name="rnl-std-semiconductors", version="0.4");
//   @USE-PACKAGE(name="rnl-std-no-labels", version="0.4");
//   @USE-PACKAGE(name="analog-canvas-extensions", version="0.7")
// }

subckt dut (VDD VSS Vout1 Vout2 F F_bar)
ISS (net0 VSS) isource dc=1m
ISS1 (net3 VSS) isource dc=1m
ISS2 (net4 VSS) isource dc=1m
M1 (Vout1 A net1 VSS) sky130_fd_pr__nfet_01v8 l=0.15 w=1 nf=1 m=1
M2 (Vout2 A_bar net1 VSS) sky130_fd_pr__nfet_01v8 l=0.15 w=1 nf=1 m=1
M3 (net1 B net0 VSS) sky130_fd_pr__nfet_01v8 l=0.15 w=1 nf=1 m=1
M4 (Vout2 B_bar net0 VSS) sky130_fd_pr__nfet_01v8 l=0.15 w=1 nf=1 m=1
M5 (B F_bar net4 VSS) sky130_fd_pr__nfet_01v8 l=0.15 w=1 nf=1 m=1
M6 (B_bar F net4 VSS) sky130_fd_pr__nfet_01v8 l=0.15 w=1 nf=1 m=1
M7 (A_bar NC0002 net3 VSS) sky130_fd_pr__nfet_01v8 l=0.15 w=1 nf=1 m=1
M8 (A NC0001 net3 VSS) sky130_fd_pr__nfet_01v8 l=0.15 w=1 nf=1 m=1
R1A (VDD A_bar) resistor r=1k
R1B (VDD A) resistor r=1k
R2A (net2 B) resistor r=1k
R2B (net2 B_bar) resistor r=1k
RD1 (VDD Vout1) resistor r=1k
RD2 (VDD Vout2) resistor r=1k
RT (VDD net2) resistor r=1k
// @RNL(author="analog-canvas") {
//   %dut_SYMBOL = @DEFINE-SYMBOL(box=[-7, -5, 7, 5]) {
//     (-7, 0) @PIN(terminal="Vout1", label="\textbf{\textit{V}}_{\textbf{out1}}", direction="left");
//     (-7, -2) @PIN(terminal="Vout2", label="\textbf{\textit{V}}_{\textbf{out2}}", direction="left");
//     (0, 5) @PIN(terminal="VDD", label="\textbf{\textit{V}}_{\textbf{DD}}", direction="up");
//     (7, 0) @PIN(terminal="F", label="\textbf{\textit{F}}", direction="right");
//     (7, -2) @PIN(terminal="F_bar", label="\overline{\textbf{\textit{F}}}", direction="right");
//     (0, 0) @RECTANGLE(width=12, height=8);
//     @LINE {(-7, 0) (-6, 0)};
//     @LINE {(-7, -2) (-6, -2)};
//     @LINE {(0, 5) (0, 4)};
//     @LINE {(7, 0) (6, 0)};
//     @LINE {(7, -2) (6, -2)}
//   };
//   # @SET-SYMBOL %dut_SYMBOL;
//   $CANVAS_TYPESETTING @ATTACH(subscript_italic=false) #(level);
//   #M1 @SET-SYMBOL(terminals=[[1, "d"], [2, "g"], [3, "s"]]) $NMOS => @PLACE(1, 0) => @ORIENT("R0");
//   #M2 @SET-SYMBOL(terminals=[[1, "d"], [2, "g"], [3, "s"]]) $NMOS => @PLACE(11, 0) => @ORIENT("MY");
//   #M3 @SET-SYMBOL(terminals=[[1, "d"], [2, "g"], [3, "s"]]) $NMOS => @PLACE(6, -10) => @ORIENT("R0");
//   #M4 @SET-SYMBOL(terminals=[[1, "d"], [2, "g"], [3, "s"]]) $NMOS => @PLACE(19, -10) => @ORIENT("MY");
//   #RD1 @SET-SYMBOL $RESISTOR => @PLACE(1, 6) => @ORIENT("R0");
//   #RD2 @SET-SYMBOL $RESISTOR => @PLACE(11, 6) => @ORIENT("R0");
//   #ISS @SET-SYMBOL $CURRENT_SOURCE => @PLACE(12, -16) => @ORIENT("R0");
//   $CANVAS_PARAMETER @ATTACH(name="amplitude", text="1m") #ISS(part);
//   $CANVAS_PARAMETER @ATTACH(name="damping", text="0") #ISS(part);
//   $CANVAS_PARAMETER @ATTACH(name="delay", text="0") #ISS(part);
//   $CANVAS_PARAMETER @ATTACH(name="fall", text="1ps") #ISS(part);
//   $CANVAS_PARAMETER @ATTACH(name="frequency", text="1k") #ISS(part);
//   $CANVAS_PARAMETER @ATTACH(name="high", text="1m") #ISS(part);
//   $CANVAS_PARAMETER @ATTACH(name="low", text="0") #ISS(part);
//   $CANVAS_PARAMETER @ATTACH(name="offset", text="0") #ISS(part);
//   $CANVAS_PARAMETER @ATTACH(name="period", text="10ns") #ISS(part);
//   $CANVAS_PARAMETER @ATTACH(name="phase", text="0") #ISS(part);
//   $CANVAS_PARAMETER @ATTACH(name="rise", text="1ps") #ISS(part);
//   $CANVAS_PARAMETER @ATTACH(name="waveform", text="dc") #ISS(part);
//   $CANVAS_PARAMETER @ATTACH(name="width", text="5ns") #ISS(part);
//   $GROUND @ATTACH &VSS(p) => @SET-SYMBOL $GROUND_SYMBOL => @PLACE(12, -18) => @ORIENT("R0") => %gnd1;
//   #M7 @SET-SYMBOL(terminals=[[1, "d"], [2, "g"], [3, "s"]]) $NMOS => @PLACE(-11, -10) => @ORIENT("R0");
//   #M8 @SET-SYMBOL(terminals=[[1, "d"], [2, "g"], [3, "s"]]) $NMOS => @PLACE(-5, -10) => @ORIENT("MY");
//   #R1A @SET-SYMBOL $RESISTOR => @PLACE(-11, 4) => @ORIENT("R0");
//   #R1B @SET-SYMBOL $RESISTOR => @PLACE(-5, 4) => @ORIENT("R0");
//   #ISS1 @SET-SYMBOL $CURRENT_SOURCE => @PLACE(-8, -16) => @ORIENT("R0");
//   $CANVAS_PARAMETER @ATTACH(name="amplitude", text="1m") #ISS1(part);
//   $CANVAS_PARAMETER @ATTACH(name="damping", text="0") #ISS1(part);
//   $CANVAS_PARAMETER @ATTACH(name="delay", text="0") #ISS1(part);
//   $CANVAS_PARAMETER @ATTACH(name="fall", text="1ps") #ISS1(part);
//   $CANVAS_PARAMETER @ATTACH(name="frequency", text="1k") #ISS1(part);
//   $CANVAS_PARAMETER @ATTACH(name="high", text="1m") #ISS1(part);
//   $CANVAS_PARAMETER @ATTACH(name="low", text="0") #ISS1(part);
//   $CANVAS_PARAMETER @ATTACH(name="offset", text="0") #ISS1(part);
//   $CANVAS_PARAMETER @ATTACH(name="period", text="10ns") #ISS1(part);
//   $CANVAS_PARAMETER @ATTACH(name="phase", text="0") #ISS1(part);
//   $CANVAS_PARAMETER @ATTACH(name="rise", text="1ps") #ISS1(part);
//   $CANVAS_PARAMETER @ATTACH(name="waveform", text="dc") #ISS1(part);
//   $CANVAS_PARAMETER @ATTACH(name="width", text="5ns") #ISS1(part);
//   $GROUND @ATTACH &VSS(p) => @SET-SYMBOL $GROUND_SYMBOL => @PLACE(-8, -18) => @ORIENT("R0") => %gnd2;
//   $IO_PORT @ATTACH &Vout1(p) => @SET-SYMBOL $IO_PORT_SYMBOL => @PLACE(4, 4) => @ORIENT("MY") => %port1;
//   $IO_PORT @ATTACH &Vout2(p) => @SET-SYMBOL $IO_PORT_SYMBOL => @PLACE(8, 4) => @ORIENT("R0") => %port2;
//   $SUPPLY @ATTACH &VDD(p) => @SET-SYMBOL $SUPPLY_SYMBOL => @PLACE(33, 8) => @ORIENT("R0") => %vdd1;
//   #RT @SET-SYMBOL $RESISTOR => @PLACE(33, 6) => @ORIENT("R0");
//   #R2A @SET-SYMBOL $RESISTOR => @PLACE(30, 2) => @ORIENT("R0");
//   #R2B @SET-SYMBOL $RESISTOR => @PLACE(36, 2) => @ORIENT("R0");
//   #M5 @SET-SYMBOL(terminals=[[1, "d"], [2, "g"], [3, "s"]]) $NMOS => @PLACE(30, -8) => @ORIENT("R0");
//   #M6 @SET-SYMBOL(terminals=[[1, "d"], [2, "g"], [3, "s"]]) $NMOS => @PLACE(36, -8) => @ORIENT("MY");
//   #ISS2 @SET-SYMBOL $CURRENT_SOURCE => @PLACE(33, -16) => @ORIENT("R0");
//   $CANVAS_PARAMETER @ATTACH(name="amplitude", text="1m") #ISS2(part);
//   $CANVAS_PARAMETER @ATTACH(name="damping", text="0") #ISS2(part);
//   $CANVAS_PARAMETER @ATTACH(name="delay", text="0") #ISS2(part);
//   $CANVAS_PARAMETER @ATTACH(name="fall", text="1ps") #ISS2(part);
//   $CANVAS_PARAMETER @ATTACH(name="frequency", text="1k") #ISS2(part);
//   $CANVAS_PARAMETER @ATTACH(name="high", text="1m") #ISS2(part);
//   $CANVAS_PARAMETER @ATTACH(name="low", text="0") #ISS2(part);
//   $CANVAS_PARAMETER @ATTACH(name="offset", text="0") #ISS2(part);
//   $CANVAS_PARAMETER @ATTACH(name="period", text="10ns") #ISS2(part);
//   $CANVAS_PARAMETER @ATTACH(name="phase", text="0") #ISS2(part);
//   $CANVAS_PARAMETER @ATTACH(name="rise", text="1ps") #ISS2(part);
//   $CANVAS_PARAMETER @ATTACH(name="waveform", text="dc") #ISS2(part);
//   $CANVAS_PARAMETER @ATTACH(name="width", text="5ns") #ISS2(part);
//   $GROUND @ATTACH &VSS(p) => @SET-SYMBOL $GROUND_SYMBOL => @PLACE(33, -18) => @ORIENT("R0") => %gnd3;
//   $IO_PORT @ATTACH &F(p) => @SET-SYMBOL $IO_PORT_SYMBOL => @PLACE(41, -8) => @ORIENT("MY") => %port3;
//   $IO_PORT @ATTACH &F_bar(p) => @SET-SYMBOL $IO_PORT_SYMBOL => @PLACE(41, -12) => @ORIENT("MY") => %port4;
//   $NO_CONNECT @ATTACH #M7:2(t) => @PLACE(-14, -10);
//   $NO_CONNECT @ATTACH #M8:2(t) => @PLACE(-2, -10);
//   %j1 = (-1, 10);
//   %j2 = (13, 10);
//   %j3 = (-13, 8);
//   %j4 = (-3, 8);
//   %j5 = (-11, 8);
//   %j6 = (-5, 8);
//   %j7 = (1, 10);
//   %j8 = (11, 10);
//   %j9 = (6, -4);
//   %j10 = (-5, 0);
//   %j11 = (-11, -6);
//   %j12 = (1, -10);
//   %j13 = (24, -10);
//   %j14 = (30, -3);
//   %j15 = (28, -3);
//   %j16 = (36, -3);
//   %j17 = (38, -3);
//   %j18 = (33, -10);
//   &VDD @WIRE(mode="straight", linestyle="bold") {%j1 %j7};
//   &VDD @WIRE(mode="straight", linestyle="bold") {%j7 %j8};
//   &VDD @WIRE(mode="straight", linestyle="bold") {%j8 %j2};
//   &VDD @WIRE(mode="straight", linestyle="bold") {%j3 %j5};
//   &VDD @WIRE(mode="straight", linestyle="bold") {%j5 %j6};
//   &VDD @WIRE(mode="straight", linestyle="bold") {%j6 %j4};
//   &VDD @WIRE(mode="straight") {#R1A:1 %j5};
//   &VDD @WIRE(mode="straight") {#R1B:1 %j6};
//   &A_bar @WIRE(mode="straight") {#R1A:2 %j11};
//   &A_bar @WIRE(mode="straight") {%j11 #M7:1};
//   &A @WIRE(mode="straight") {#R1B:2 %j10};
//   &A @WIRE(mode="straight") {%j10 #M8:1};
//   &net3 @WIRE(mode="straight") {#M7:3 (-11, -14) #ISS1:1};
//   &net3 @WIRE(mode="straight") {#M8:3 (-5, -14) #ISS1:1};
//   &VDD @WIRE(mode="straight") {#RD1:1 %j7};
//   &VDD @WIRE(mode="straight") {#RD2:1 %j8};
//   &Vout1 @WIRE(mode="straight") {#RD1:2 #M1:1};
//   &Vout2 @WIRE(mode="straight") {#RD2:2 #M2:1};
//   &Vout1 @WIRE(mode="straight") {%port1::pin #RD1:2};
//   &Vout2 @WIRE(mode="straight") {%port2::pin #RD2:2};
//   &net1 @WIRE(mode="straight") {#M1:3 (1, -4) %j9};
//   &net1 @WIRE(mode="straight") {%j9 #M3:1};
//   &net1 @WIRE(mode="straight") {#M2:3 (11, -4) %j9};
//   &net0 @WIRE(mode="straight") {#M3:3 (6, -14) #ISS:1};
//   &net0 @WIRE(mode="straight") {#M4:3 (19, -14) #ISS:1};
//   &Vout2 @WIRE(mode="straight") {#M4:1 (19, 4) #RD2:2};
//   &A @WIRE(mode="straight") {#M1:2 %j10} => %wire1;
//   &A_bar @WIRE(mode="straight") {#M2:2 (14, -6) %j11} => %wire2;
//   &B @WIRE(mode="straight") {#M3:2 %j12} => %wire3;
//   &B_bar @WIRE(mode="straight") {#M4:2 %j13} => %wire4;
//   &net2 @WIRE(mode="straight") {#R2A:1 #RT:2};
//   &net2 @WIRE(mode="straight") {#R2B:1 #RT:2};
//   &B @WIRE(mode="straight") {#R2A:2 %j14};
//   &B @WIRE(mode="straight") {%j14 #M5:1};
//   &B_bar @WIRE(mode="straight") {#R2B:2 %j16};
//   &B_bar @WIRE(mode="straight") {%j16 #M6:1};
//   &B @WIRE(mode="straight") {%j14 %j15} => %wire5;
//   &B_bar @WIRE(mode="straight") {%j16 %j17} => %wire6;
//   &net4 @WIRE(mode="straight") {#M5:3 %j18};
//   &net4 @WIRE(mode="straight") {%j18 #M6:3};
//   &net4 @WIRE(mode="straight") {#ISS2:1 %j18};
//   &F @WIRE(mode="straight") {#M6:2 %port3::pin};
//   &F_bar @WIRE(mode="straight") {#M5:2 (26, -8) (26, -12) %port4::pin};
//   $JUNCTION @ATTACH (1, 4)(p) => @PLACE(1, 4) => %dot1;
//   $JUNCTION @ATTACH %j5(p) => @PLACE(-11, 8) => %dot2;
//   $JUNCTION @ATTACH %j6(p) => @PLACE(-5, 8) => %dot3;
//   $JUNCTION @ATTACH %j7(p) => @PLACE(1, 10) => %dot4;
//   $JUNCTION @ATTACH %j8(p) => @PLACE(11, 10) => %dot5;
//   &VDD @WIRE(mode="straight") {#RT:1 %vdd1::pin};
//   $JUNCTION @ATTACH (11, 4)(p) => @PLACE(11, 4) => %dot6;
//   &VSS @WIRE(mode="straight") {%gnd2::pin #ISS1:2};
//   &VSS @WIRE(mode="straight") {%gnd1::pin #ISS:2};
//   &VSS @WIRE(mode="straight") {%gnd3::pin #ISS2:2};
//   $JUNCTION @ATTACH (12, -14)(p) => @PLACE(12, -14) => %dot7;
//   $JUNCTION @ATTACH %j16(p) => @PLACE(36, -3) => %dot8;
//   $JUNCTION @ATTACH %j11(p) => @PLACE(-11, -6) => %dot9;
//   $JUNCTION @ATTACH %j9(p) => @PLACE(6, -4) => %dot10;
//   $JUNCTION @ATTACH %j10(p) => @PLACE(-5, 0) => %dot11;
//   $JUNCTION @ATTACH (33, 4)(p) => @PLACE(33, 4) => %dot12;
//   $JUNCTION @ATTACH (-8, -14)(p) => @PLACE(-8, -14) => %dot13;
//   $JUNCTION @ATTACH %j18(p) => @PLACE(33, -10) => %dot14;
//   $JUNCTION @ATTACH %j14(p) => @PLACE(30, -3) => %dot15;
//   #M1
//       @TEXT("\textbf{\textit{M}}_{\textbf{1}}", key="name", dx=0.5, dy=-0.5, halign="start", valign="baseline", size=1.5116,
//       bold=false, textvisible=true);
//   $CANVAS_LABEL @ATTACH(bind="name") #M1::name(label);
//   #M2
//       @TEXT("\textbf{\textit{M}}_{\textbf{2}}", key="name", dx=-0.5, dy=-0.5, halign="end", valign="baseline", size=1.5116,
//       bold=false, textvisible=true);
//   $CANVAS_LABEL @ATTACH(bind="name") #M2::name(label);
//   #M3
//       @TEXT("\textbf{\textit{M}}_{\textbf{3}}", key="name", dx=0.5, dy=-0.5, halign="start", valign="baseline", size=1.5116,
//       bold=false, textvisible=true);
//   $CANVAS_LABEL @ATTACH(bind="name") #M3::name(label);
//   #M4
//       @TEXT("\textbf{\textit{M}}_{\textbf{4}}", key="name", dx=-0.5, dy=-0.5, halign="end", valign="baseline", size=1.5116,
//       bold=false, textvisible=true);
//   $CANVAS_LABEL @ATTACH(bind="name") #M4::name(label);
//   #RD1
//       @TEXT("\textbf{\textit{R}}_{\textbf{D}}", key="name", dx=-0.9, dy=-0.5, halign="end", valign="baseline", size=1.5116,
//       bold=false, textvisible=true);
//   #RD2
//       @TEXT("\textbf{\textit{R}}_{\textbf{D}}", key="name", dx=0.9, dy=-0.5, halign="start", valign="baseline", size=1.5116,
//       bold=false, textvisible=true);
//   #ISS
//       @TEXT("\textbf{\textit{I}}_{\textbf{SS}}", key="name", dx=1.5, dy=-0.5, halign="start", valign="baseline", size=1.5116,
//       bold=false, textvisible=true);
//   $CANVAS_LABEL @ATTACH(bind="name") #ISS::name(label);
//   #M7
//       @TEXT("\textbf{\textit{M}}_{\textbf{7}}", key="name", dx=0.5, dy=-0.5, halign="start", valign="baseline", size=1.5116,
//       bold=false, textvisible=true);
//   $CANVAS_LABEL @ATTACH(bind="name") #M7::name(label);
//   #M8
//       @TEXT("\textbf{\textit{M}}_{\textbf{8}}", key="name", dx=2, dy=-3, halign="start", valign="baseline", size=1.5116,
//       bold=false, textvisible=true);
//   $CANVAS_LABEL @ATTACH(bind="name") #M8::name(label);
//   #R1A
//       @TEXT("\textbf{\textit{R}}_{\textbf{1}}", key="name", dx=0.9, dy=-0.5, halign="start", valign="baseline", size=1.5116,
//       bold=false, textvisible=true);
//   #R1B
//       @TEXT("\textbf{\textit{R}}_{\textbf{1}}", key="name", dx=0.9, dy=-0.5, halign="start", valign="baseline", size=1.5116,
//       bold=false, textvisible=true);
//   #ISS1
//       @TEXT("\textbf{\textit{I}}_{\textbf{SS1}}", key="name", dx=1.5, dy=-0.5, halign="start", valign="baseline", size=1.5116,
//       bold=false, textvisible=true);
//   $CANVAS_LABEL @ATTACH(bind="name") #ISS1::name(label);
//   %port1
//       @TEXT("\textbf{\textit{V}}_{\textbf{out1}}", key="netname", dx=-0.3, dy=1.2, halign="middle", valign="baseline",
//       size=1.5116, bold=false, textvisible=true);
//   $CANVAS_LABEL @ATTACH(bind="port") %port1::netname(label);
//   %port2
//       @TEXT("\textbf{\textit{V}}_{\textbf{out2}}", key="netname", dx=0.3, dy=1.2, halign="middle", valign="baseline",
//       size=1.5116, bold=false, textvisible=true);
//   $CANVAS_LABEL @ATTACH(bind="port") %port2::netname(label);
//   %vdd1 @TEXT("\textbf{\textit{V}}_{\textbf{DD}}", dx=0, dy=3.2, halign="middle", size=1.5116, bold=false) => %power1;
//   $CANVAS_LABEL @ATTACH(bind="port") %power1(label);
//   #RT
//       @TEXT("\textbf{\textit{R}}_{\textbf{T}}", key="name", dx=0.9, dy=-0.5, halign="start", valign="baseline", size=1.5116,
//       bold=false, textvisible=true);
//   $CANVAS_LABEL @ATTACH(bind="name") #RT::name(label);
//   #R2A
//       @TEXT("\textbf{\textit{R}}_{\textbf{2}}", key="name", dx=0.9, dy=-0.5, halign="start", valign="baseline", size=1.5116,
//       bold=false, textvisible=true);
//   #R2B
//       @TEXT("\textbf{\textit{R}}_{\textbf{2}}", key="name", dx=0.9, dy=-0.5, halign="start", valign="baseline", size=1.5116,
//       bold=false, textvisible=true);
//   #M5
//       @TEXT("\textbf{\textit{M}}_{\textbf{5}}", key="name", dx=0.5, dy=-0.5, halign="start", valign="baseline", size=1.5116,
//       bold=false, textvisible=true);
//   $CANVAS_LABEL @ATTACH(bind="name") #M5::name(label);
//   #M6
//       @TEXT("\textbf{\textit{M}}_{\textbf{6}}", key="name", dx=2.6, dy=-2.4, halign="start", valign="baseline", size=1.5116,
//       bold=false, textvisible=true);
//   $CANVAS_LABEL @ATTACH(bind="name") #M6::name(label);
//   #ISS2
//       @TEXT("\textbf{\textit{I}}_{\textbf{SS2}}", key="name", dx=1.5, dy=-0.5, halign="start", valign="baseline", size=1.5116,
//       bold=false, textvisible=true);
//   $CANVAS_LABEL @ATTACH(bind="name") #ISS2::name(label);
//   %port3
//       @TEXT("\textbf{\textit{F}}", key="netname", dx=2, dy=-0.5, halign="start", valign="baseline", size=1.5116, bold=false,
//       textvisible=true);
//   $CANVAS_LABEL @ATTACH(bind="port") %port3::netname(label);
//   %port4
//       @TEXT("\overline{\textbf{\textit{F}}}", key="netname", dx=2, dy=-0.5, halign="start", valign="baseline", size=1.5116,
//       bold=false, textvisible=true);
//   $CANVAS_LABEL @ATTACH(bind="port") %port4::netname(label);
//   &VDD @TEXT("\textbf{\textit{V}}_{\textbf{DD}}", size=1.5116, bold=false) => @PLACE(14, 9) => %power2;
//   $CANVAS_LABEL @ATTACH(bind="port") %power2(label);
//   &VDD @TEXT("\textbf{\textit{V}}_{\textbf{DD}}", halign="end", size=1.5116, bold=false) => @PLACE(-13.6, 7.5) => %power3;
//   $CANVAS_LABEL @ATTACH(bind="port") %power3(label);
//   %wire1 @TEXT("\textbf{\textit{A}}", halign="middle", size=1.5116, bold=false) => @PLACE(-3.5, 0.4) => %label1;
//   $CANVAS_LABEL @ATTACH(bind="net") %label1(label);
//   %wire2 @TEXT("\overline{\textbf{\textit{A}}}", halign="middle", size=1.5116, bold=false) => @PLACE(-2, -5.6) => %label2;
//   $CANVAS_LABEL @ATTACH(bind="net") %label2(label);
//   %wire3 @TEXT("\textbf{\textit{B}}", halign="middle", size=1.5116, bold=false) => @PLACE(2, -9.6) => %label3;
//   $CANVAS_LABEL @ATTACH(bind="net") %label3(label);
//   %wire4 @TEXT("\overline{\textbf{\textit{B}}}", halign="middle", size=1.5116, bold=false) => @PLACE(24, -9.6) => %label4;
//   $CANVAS_LABEL @ATTACH(bind="net") %label4(label);
//   %wire5 @TEXT("\textbf{\textit{B}}", halign="middle", size=1.5116, bold=false) => @PLACE(28, -2.6) => %label5;
//   $CANVAS_LABEL @ATTACH(bind="net") %label5(label);
//   %wire6 @TEXT("\overline{\textbf{\textit{B}}}", halign="middle", size=1.5116, bold=false) => @PLACE(38, -2.6) => %label6;
//   $CANVAS_LABEL @ATTACH(bind="net") %label6(label);
//   %vdd1 @TEXT("${p}", key="netname", textvisible=false)
// }
ends dut
