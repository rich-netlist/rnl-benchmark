simulator lang=spectre
// @RNL(type="header") {
//   @VERSION("0.4");
//   @USE-PACKAGE(name="rnl-std-style", version="0.4");
//   @USE-PACKAGE(name="rnl-std-basic", version="0.4");
//   @USE-PACKAGE(name="rnl-std-semiconductors", version="0.4");
//   @USE-PACKAGE(name="rnl-std-no-labels", version="0.4");
//   @USE-PACKAGE(name="analog-canvas-extensions", version="0.7")
// }

subckt ring_vco_replica (VDD VSS vop von vref vctrl)
Cc (vbp VSS) capacitor c=0.2p
M11 (a1 vop net6 VSS) sky130_fd_pr__nfet_01v8 l=0.15 w=8 nf=1 m=1
M12 (net1 von net6 VSS) sky130_fd_pr__nfet_01v8 l=0.15 w=8 nf=1 m=1
M13 (a1 vbp VDD VDD) sky130_fd_pr__pfet_01v8 l=0.15 w=2 nf=1 m=1
M14 (net1 vbp VDD VDD) sky130_fd_pr__pfet_01v8 l=0.15 w=2 nf=1 m=1
M15 (net6 vctrl VSS VSS) sky130_fd_pr__nfet_01v8 l=0.5 w=4 nf=1 m=1
M21 (a2 net1 net0 VSS) sky130_fd_pr__nfet_01v8 l=0.15 w=8 nf=1 m=1
M22 (net7 a1 net0 VSS) sky130_fd_pr__nfet_01v8 l=0.15 w=8 nf=1 m=1
M23 (a2 vbp VDD VDD) sky130_fd_pr__pfet_01v8 l=0.15 w=2 nf=1 m=1
M24 (net7 vbp VDD VDD) sky130_fd_pr__pfet_01v8 l=0.15 w=2 nf=1 m=1
M25 (net0 vctrl VSS VSS) sky130_fd_pr__nfet_01v8 l=0.5 w=4 nf=1 m=1
M31 (vop net7 net3 VSS) sky130_fd_pr__nfet_01v8 l=0.15 w=8 nf=1 m=1
M32 (von a2 net3 VSS) sky130_fd_pr__nfet_01v8 l=0.15 w=8 nf=1 m=1
M33 (vop vbp VDD VDD) sky130_fd_pr__pfet_01v8 l=0.15 w=2 nf=1 m=1
M34 (von vbp VDD VDD) sky130_fd_pr__pfet_01v8 l=0.15 w=2 nf=1 m=1
M35 (net3 vctrl VSS VSS) sky130_fd_pr__nfet_01v8 l=0.5 w=4 nf=1 m=1
MO1 (net5 vrep net4 VSS) sky130_fd_pr__nfet_01v8 l=0.5 w=2 nf=1 m=1
MO2 (vbp vref net4 VSS) sky130_fd_pr__nfet_01v8 l=0.5 w=2 nf=1 m=1
MO3 (net5 net5 VDD VDD) sky130_fd_pr__pfet_01v8_lvt l=0.5 w=2 nf=1 m=1
MO4 (vbp net5 VDD VDD) sky130_fd_pr__pfet_01v8_lvt l=0.5 w=2 nf=1 m=1
MO5 (net4 vctrl VSS VSS) sky130_fd_pr__nfet_01v8 l=0.5 w=8 nf=1 m=1
MR1 (vrep VDD net2 VSS) sky130_fd_pr__nfet_01v8 l=0.15 w=8 nf=1 m=1
MR2 (vrep vbp VDD VDD) sky130_fd_pr__pfet_01v8 l=0.15 w=2 nf=1 m=1
MR3 (net2 vctrl VSS VSS) sky130_fd_pr__nfet_01v8 l=0.5 w=4 nf=1 m=1
// @RNL(author="analog-canvas") {
//   %ring_vco_replica_SYMBOL = @DEFINE-SYMBOL(box=[-6, -5, 6, 5]) {
//     (-6, 2) @PIN(terminal="VDD", label="\textbf{\textit{V}}_{\textbf{DD}}", direction="left");
//     (-6, 0) @PIN(terminal="vop", label="\textbf{\textit{v}}_{\textbf{op}}", direction="left");
//     (-6, -2) @PIN(terminal="von", label="\textbf{\textit{v}}_{\textbf{on}}", direction="left");
//     (6, 1) @PIN(terminal="vref", label="\textbf{\textit{v}}_{\textbf{ref}}", direction="right");
//     (6, -1) @PIN(terminal="vctrl", label="\textbf{\textit{v}}_{\textbf{ctrl}}", direction="right");
//     (0, 0) @RECTANGLE(width=10, height=8);
//     @LINE {(-6, 2) (-5, 2)};
//     @LINE {(-6, 0) (-5, 0)};
//     @LINE {(-6, -2) (-5, -2)};
//     @LINE {(6, 1) (5, 1)};
//     @LINE {(6, -1) (5, -1)}
//   };
//   # @SET-SYMBOL %ring_vco_replica_SYMBOL;
//   $CANVAS_TYPESETTING @ATTACH(subscript_italic=false) #(level);
//   $SUPPLY @ATTACH &VDD(p) => @SET-SYMBOL $SUPPLY_SYMBOL => @PLACE(20, 26) => @ORIENT("R0") => %vdd1;
//   $SUPPLY @ATTACH &VDD(p) => @SET-SYMBOL $SUPPLY_SYMBOL => @PLACE(32, 26) => @ORIENT("R0") => %vdd2;
//   $SUPPLY @ATTACH &VDD(p) => @SET-SYMBOL $SUPPLY_SYMBOL => @PLACE(48, 26) => @ORIENT("R0") => %vdd3;
//   $SUPPLY @ATTACH &VDD(p) => @SET-SYMBOL $SUPPLY_SYMBOL => @PLACE(60, 26) => @ORIENT("R0") => %vdd4;
//   $SUPPLY @ATTACH &VDD(p) => @SET-SYMBOL $SUPPLY_SYMBOL => @PLACE(76, 26) => @ORIENT("R0") => %vdd5;
//   $SUPPLY @ATTACH &VDD(p) => @SET-SYMBOL $SUPPLY_SYMBOL => @PLACE(88, 26) => @ORIENT("R0") => %vdd6;
//   $SUPPLY @ATTACH &VDD(p) => @SET-SYMBOL $SUPPLY_SYMBOL => @PLACE(106, 26) => @ORIENT("R0") => %vdd7;
//   $SUPPLY @ATTACH &VDD(p) => @SET-SYMBOL $SUPPLY_SYMBOL => @PLACE(100, 16) => @ORIENT("R0") => %vdd8;
//   $SUPPLY @ATTACH &VDD(p) => @SET-SYMBOL $SUPPLY_SYMBOL => @PLACE(118, 26) => @ORIENT("R0") => %vdd9;
//   $SUPPLY @ATTACH &VDD(p) => @SET-SYMBOL $SUPPLY_SYMBOL => @PLACE(130, 26) => @ORIENT("R0") => %vdd10;
//   #M13 @SET-SYMBOL(terminals=[[1, "d"], [2, "g"], [3, "s"]]) $PMOS => @PLACE(20, 24) => @ORIENT("MY");
//   $CANVAS_PARAMETER_TEXT @ATTACH(name="l", text="0.15u") #M13(part);
//   #M14 @SET-SYMBOL(terminals=[[1, "d"], [2, "g"], [3, "s"]]) $PMOS => @PLACE(32, 24) => @ORIENT("R0");
//   $CANVAS_PARAMETER_TEXT @ATTACH(name="l", text="0.15u") #M14(part);
//   #M11 @SET-SYMBOL(terminals=[[1, "d"], [2, "g"], [3, "s"]]) $NMOS => @PLACE(20, 14) => @ORIENT("R0");
//   $CANVAS_PARAMETER_TEXT @ATTACH(name="l", text="0.15u") #M11(part);
//   #M12 @SET-SYMBOL(terminals=[[1, "d"], [2, "g"], [3, "s"]]) $NMOS => @PLACE(32, 14) => @ORIENT("MY");
//   $CANVAS_PARAMETER_TEXT @ATTACH(name="l", text="0.15u") #M12(part);
//   #M15 @SET-SYMBOL(terminals=[[1, "d"], [2, "g"], [3, "s"]]) $NMOS => @PLACE(26, 6) => @ORIENT("R0");
//   $CANVAS_PARAMETER_TEXT @ATTACH(name="l", text="0.5u") #M15(part);
//   $GROUND @ATTACH &VSS(p) => @SET-SYMBOL $GROUND_SYMBOL => @PLACE(26, 4) => @ORIENT("R0") => %gnd1;
//   #M23 @SET-SYMBOL(terminals=[[1, "d"], [2, "g"], [3, "s"]]) $PMOS => @PLACE(48, 24) => @ORIENT("MY");
//   $CANVAS_PARAMETER_TEXT @ATTACH(name="l", text="0.15u") #M23(part);
//   #M24 @SET-SYMBOL(terminals=[[1, "d"], [2, "g"], [3, "s"]]) $PMOS => @PLACE(60, 24) => @ORIENT("R0");
//   $CANVAS_PARAMETER_TEXT @ATTACH(name="l", text="0.15u") #M24(part);
//   #M21 @SET-SYMBOL(terminals=[[1, "d"], [2, "g"], [3, "s"]]) $NMOS => @PLACE(48, 14) => @ORIENT("R0");
//   $CANVAS_PARAMETER_TEXT @ATTACH(name="l", text="0.15u") #M21(part);
//   #M22 @SET-SYMBOL(terminals=[[1, "d"], [2, "g"], [3, "s"]]) $NMOS => @PLACE(60, 14) => @ORIENT("MY");
//   $CANVAS_PARAMETER_TEXT @ATTACH(name="l", text="0.15u") #M22(part);
//   #M25 @SET-SYMBOL(terminals=[[1, "d"], [2, "g"], [3, "s"]]) $NMOS => @PLACE(54, 6) => @ORIENT("R0");
//   $CANVAS_PARAMETER_TEXT @ATTACH(name="l", text="0.5u") #M25(part);
//   $GROUND @ATTACH &VSS(p) => @SET-SYMBOL $GROUND_SYMBOL => @PLACE(54, 4) => @ORIENT("R0") => %gnd2;
//   #M33 @SET-SYMBOL(terminals=[[1, "d"], [2, "g"], [3, "s"]]) $PMOS => @PLACE(76, 24) => @ORIENT("MY");
//   $CANVAS_PARAMETER_TEXT @ATTACH(name="l", text="0.15u") #M33(part);
//   #M34 @SET-SYMBOL(terminals=[[1, "d"], [2, "g"], [3, "s"]]) $PMOS => @PLACE(88, 24) => @ORIENT("R0");
//   $CANVAS_PARAMETER_TEXT @ATTACH(name="l", text="0.15u") #M34(part);
//   #M31 @SET-SYMBOL(terminals=[[1, "d"], [2, "g"], [3, "s"]]) $NMOS => @PLACE(76, 14) => @ORIENT("R0");
//   $CANVAS_PARAMETER_TEXT @ATTACH(name="l", text="0.15u") #M31(part);
//   #M32 @SET-SYMBOL(terminals=[[1, "d"], [2, "g"], [3, "s"]]) $NMOS => @PLACE(88, 14) => @ORIENT("MY");
//   $CANVAS_PARAMETER_TEXT @ATTACH(name="l", text="0.15u") #M32(part);
//   #M35 @SET-SYMBOL(terminals=[[1, "d"], [2, "g"], [3, "s"]]) $NMOS => @PLACE(82, 6) => @ORIENT("R0");
//   $CANVAS_PARAMETER_TEXT @ATTACH(name="l", text="0.5u") #M35(part);
//   $GROUND @ATTACH &VSS(p) => @SET-SYMBOL $GROUND_SYMBOL => @PLACE(82, 4) => @ORIENT("R0") => %gnd3;
//   $IO_PORT @ATTACH &vop(p) => @SET-SYMBOL $IO_PORT_SYMBOL => @PLACE(15, 14) => @ORIENT("R0") => %port1;
//   $IO_PORT @ATTACH &von(p) => @SET-SYMBOL $IO_PORT_SYMBOL => @PLACE(37, 14) => @ORIENT("MY") => %port2;
//   $IO_PORT @ATTACH &vop(p) => @SET-SYMBOL $IO_PORT_SYMBOL => @PLACE(72, 21) => @ORIENT("R0") => %port3;
//   $IO_PORT @ATTACH &von(p) => @SET-SYMBOL $IO_PORT_SYMBOL => @PLACE(94, 19) => @ORIENT("MY") => %port4;
//   #MR2 @SET-SYMBOL(terminals=[[1, "d"], [2, "g"], [3, "s"]]) $PMOS => @PLACE(106, 24) => @ORIENT("R0");
//   $CANVAS_PARAMETER_TEXT @ATTACH(name="l", text="0.15u") #MR2(part);
//   #MR1 @SET-SYMBOL(terminals=[[1, "d"], [2, "g"], [3, "s"]]) $NMOS => @PLACE(106, 14) => @ORIENT("R0");
//   $CANVAS_PARAMETER_TEXT @ATTACH(name="l", text="0.15u") #MR1(part);
//   #MR3 @SET-SYMBOL(terminals=[[1, "d"], [2, "g"], [3, "s"]]) $NMOS => @PLACE(106, 6) => @ORIENT("R0");
//   $CANVAS_PARAMETER_TEXT @ATTACH(name="l", text="0.5u") #MR3(part);
//   $GROUND @ATTACH &VSS(p) => @SET-SYMBOL $GROUND_SYMBOL => @PLACE(106, 4) => @ORIENT("R0") => %gnd4;
//   #MO3 @SET-SYMBOL(terminals=[[1, "d"], [2, "g"], [3, "s"]]) $PMOS => @PLACE(118, 24) => @ORIENT("MY");
//   $CANVAS_PARAMETER_TEXT @ATTACH(name="l", text="0.5u") #MO3(part);
//   #MO4 @SET-SYMBOL(terminals=[[1, "d"], [2, "g"], [3, "s"]]) $PMOS => @PLACE(130, 24) => @ORIENT("R0");
//   $CANVAS_PARAMETER_TEXT @ATTACH(name="l", text="0.5u") #MO4(part);
//   #MO1 @SET-SYMBOL(terminals=[[1, "d"], [2, "g"], [3, "s"]]) $NMOS => @PLACE(118, 14) => @ORIENT("R0");
//   $CANVAS_PARAMETER_TEXT @ATTACH(name="l", text="0.5u") #MO1(part);
//   #MO2 @SET-SYMBOL(terminals=[[1, "d"], [2, "g"], [3, "s"]]) $NMOS => @PLACE(130, 14) => @ORIENT("MY");
//   $CANVAS_PARAMETER_TEXT @ATTACH(name="l", text="0.5u") #MO2(part);
//   $IO_PORT @ATTACH &vref(p) => @SET-SYMBOL $IO_PORT_SYMBOL => @PLACE(135, 14) => @ORIENT("MY") => %port5;
//   #MO5 @SET-SYMBOL(terminals=[[1, "d"], [2, "g"], [3, "s"]]) $NMOS => @PLACE(124, 6) => @ORIENT("R0");
//   $CANVAS_PARAMETER_TEXT @ATTACH(name="l", text="0.5u") #MO5(part);
//   $GROUND @ATTACH &VSS(p) => @SET-SYMBOL $GROUND_SYMBOL => @PLACE(124, 4) => @ORIENT("R0") => %gnd5;
//   #Cc @SET-SYMBOL $CAPACITOR => @PLACE(142, 22) => @ORIENT("R0");
//   $CANVAS_PARAMETER_TEXT @ATTACH(name="c", text="0.2pF") #Cc(part);
//   $GROUND @ATTACH &VSS(p) => @SET-SYMBOL $GROUND_SYMBOL => @PLACE(142, 20) => @ORIENT("R0") => %gnd6;
//   $IO_PORT @ATTACH &vctrl(p) => @SET-SYMBOL $IO_PORT_SYMBOL => @PLACE(144, -2) => @ORIENT("MY") => %port6;
//   %j1 = (26, 10);
//   %j2 = (54, 10);
//   %j3 = (82, 10);
//   %j4 = (124, 10);
//   %j5 = (124, 24);
//   %j6 = (118, 20);
//   %j7 = (106, 19);
//   %j8 = (32, 19);
//   %j9 = (60, 19);
//   %j10 = (76, 21);
//   %j11 = (88, 19);
//   %j12 = (130, 19);
//   %j13 = (26, 24);
//   %j14 = (54, 32);
//   %j15 = (54, 24);
//   %j16 = (82, 32);
//   %j17 = (82, 24);
//   %j18 = (103, 32);
//   %j19 = (138, 24);
//   %j20 = (50, -2);
//   %j21 = (78, -2);
//   %j22 = (102, -2);
//   %j23 = (120, -2);
//   %j24 = (66, 14);
//   %j25 = (94, 14);
//   &vbp @WIRE(mode="straight") {#M13:2 %j13};
//   &vbp @WIRE(mode="straight") {%j13 #M14:2};
//   &a1 @WIRE(mode="straight") {#M13:1 #M11:1} => %wire1;
//   &net1 @WIRE(mode="straight") {#M14:1 %j8};
//   &net1 @WIRE(mode="straight") {%j8 #M12:1};
//   &net6 @WIRE(mode="straight") {#M11:3 (20, 10) %j1};
//   &net6 @WIRE(mode="straight") {%j1 (32, 10) #M12:3};
//   &net6 @WIRE(mode="straight") {#M15:1 %j1};
//   &vbp @WIRE(mode="straight") {#M23:2 %j15};
//   &vbp @WIRE(mode="straight") {%j15 #M24:2};
//   &a2 @WIRE(mode="straight") {#M23:1 #M21:1} => %wire2;
//   &net7 @WIRE(mode="straight") {#M24:1 %j9};
//   &net7 @WIRE(mode="straight") {%j9 #M22:1};
//   &net0 @WIRE(mode="straight") {#M21:3 (48, 10) %j2};
//   &net0 @WIRE(mode="straight") {%j2 (60, 10) #M22:3};
//   &net0 @WIRE(mode="straight") {#M25:1 %j2};
//   &vbp @WIRE(mode="straight") {#M33:2 %j17};
//   &vbp @WIRE(mode="straight") {%j17 #M34:2};
//   &vop @WIRE(mode="straight") {#M33:1 %j10};
//   &vop @WIRE(mode="straight") {%j10 #M31:1};
//   &von @WIRE(mode="straight") {#M34:1 %j11};
//   &von @WIRE(mode="straight") {%j11 #M32:1};
//   &net3 @WIRE(mode="straight") {#M31:3 (76, 10) %j3};
//   &net3 @WIRE(mode="straight") {%j3 (88, 10) #M32:3};
//   &net3 @WIRE(mode="straight") {#M35:1 %j3};
//   &net5 @WIRE(mode="straight") {#MO3:2 %j5};
//   &net5 @WIRE(mode="straight") {%j5 #MO4:2};
//   &net5 @WIRE(mode="straight") {#MO3:1 %j6};
//   &net5 @WIRE(mode="straight") {%j6 #MO1:1};
//   &vbp @WIRE(mode="straight") {#MO4:1 %j12};
//   &vbp @WIRE(mode="straight") {%j12 #MO2:1};
//   &net4 @WIRE(mode="straight") {#MO1:3 (118, 10) %j4};
//   &net4 @WIRE(mode="straight") {%j4 (130, 10) #MO2:3};
//   &net4 @WIRE(mode="straight") {#MO5:1 %j4};
//   &vrep @WIRE(mode="straight") {#MR2:1 %j7};
//   &vrep @WIRE(mode="straight") {%j7 #MR1:1};
//   &net2 @WIRE(mode="straight") {#MR1:3 #MR3:1};
//   &VDD @WIRE(mode="straight") {%vdd8::pin (100, 14) #MR1:2};
//   &net5 @WIRE(mode="straight") {%j5 (124, 20) %j6};
//   &vrep @WIRE(mode="straight") {%j7 (112, 19) (112, 14) #MO1:2} => %wire3;
//   &vref @WIRE(mode="straight") {%port5::pin #MO2:2};
//   &vop @WIRE(mode="straight") {%port1::pin #M11:2};
//   &von @WIRE(mode="straight") {%port2::pin #M12:2};
//   &net1 @WIRE(mode="straight") {%j8 (43, 19) (43, 14) #M21:2};
//   &net7 @WIRE(mode="straight") {%j9 (71, 19) (71, 14) #M31:2};
//   &vop @WIRE(mode="straight") {%j10 %port3::pin};
//   &von @WIRE(mode="straight") {%j11 %port4::pin};
//   &vbp @WIRE(mode="straight") {%j12 (138, 19) %j19};
//   &vbp @WIRE(mode="straight") {%j19 (138, 32) %j18};
//   &vbp @WIRE(mode="straight") {%j18 %j16};
//   &vbp @WIRE(mode="straight") {%j16 %j14} => %wire4;
//   &vbp @WIRE(mode="straight") {%j14 (26, 32) %j13};
//   &vbp @WIRE(mode="straight") {%j14 %j15};
//   &vbp @WIRE(mode="straight") {%j16 %j17};
//   &vbp @WIRE(mode="straight") {%j18 #MR2:2};
//   &vbp @WIRE(mode="straight") {%j19 #Cc:1};
//   &vctrl @WIRE(mode="straight") {#M15:2 (22, 6) (22, -2) %j20};
//   &vctrl @WIRE(mode="straight") {%j20 %j21};
//   &vctrl @WIRE(mode="straight") {%j21 %j22};
//   &vctrl @WIRE(mode="straight") {%j22 %j23};
//   &vctrl @WIRE(mode="straight") {%j23 %port6::pin};
//   &vctrl @WIRE(mode="straight") {#M25:2 (50, 6) %j20};
//   &vctrl @WIRE(mode="straight") {#M35:2 (78, 6) %j21};
//   &vctrl @WIRE(mode="straight") {#MR3:2 (102, 6) %j22};
//   &vctrl @WIRE(mode="straight") {#MO5:2 (120, 6) %j23};
//   &a1 @WIRE(mode="straight") {#M22:2 %j24} => %wire5;
//   &a2 @WIRE(mode="straight") {#M32:2 %j25} => %wire6;
//   &VDD @WIRE(mode="straight") {#M33:3 %vdd5::pin};
//   &VDD @WIRE(mode="straight") {%vdd3::pin #M23:3};
//   &VDD @WIRE(mode="straight") {%vdd2::pin #M14:3};
//   $JUNCTION @ATTACH %j11(p) => @PLACE(88, 19) => %dot1;
//   $JUNCTION @ATTACH %j20(p) => @PLACE(50, -2) => %dot2;
//   $JUNCTION @ATTACH %j21(p) => @PLACE(78, -2) => %dot3;
//   $JUNCTION @ATTACH %j22(p) => @PLACE(102, -2) => %dot4;
//   $JUNCTION @ATTACH %j23(p) => @PLACE(120, -2) => %dot5;
//   &VDD @WIRE(mode="straight") {#MR2:3 %vdd7::pin};
//   $JUNCTION @ATTACH %j10(p) => @PLACE(76, 21) => %dot6;
//   &VDD @WIRE(mode="straight") {#M13:3 %vdd1::pin};
//   &VDD @WIRE(mode="straight") {#MO4:3 %vdd10::pin};
//   &VDD @WIRE(mode="straight") {%vdd4::pin #M24:3};
//   &VDD @WIRE(mode="straight") {#MO3:3 %vdd9::pin};
//   &VDD @WIRE(mode="straight") {#M34:3 %vdd6::pin};
//   &VSS @WIRE(mode="straight") {%gnd3::pin #M35:3};
//   &VSS @WIRE(mode="straight") {%gnd4::pin #MR3:3};
//   &VSS @WIRE(mode="straight") {#M25:3 %gnd2::pin};
//   &VSS @WIRE(mode="straight") {%gnd6::pin #Cc:2};
//   &VSS @WIRE(mode="straight") {#M15:3 %gnd1::pin};
//   &VSS @WIRE(mode="straight") {#MO5:3 %gnd5::pin};
//   $JUNCTION @ATTACH %j13(p) => @PLACE(26, 24) => %dot7;
//   $JUNCTION @ATTACH %j14(p) => @PLACE(54, 32) => %dot8;
//   $JUNCTION @ATTACH %j15(p) => @PLACE(54, 24) => %dot9;
//   $JUNCTION @ATTACH %j16(p) => @PLACE(82, 32) => %dot10;
//   $JUNCTION @ATTACH %j17(p) => @PLACE(82, 24) => %dot11;
//   $JUNCTION @ATTACH %j18(p) => @PLACE(103, 32) => %dot12;
//   $JUNCTION @ATTACH %j12(p) => @PLACE(130, 19) => %dot13;
//   $JUNCTION @ATTACH %j19(p) => @PLACE(138, 24) => %dot14;
//   $JUNCTION @ATTACH %j2(p) => @PLACE(54, 10) => %dot15;
//   $JUNCTION @ATTACH %j8(p) => @PLACE(32, 19) => %dot16;
//   $JUNCTION @ATTACH %j7(p) => @PLACE(106, 19) => %dot17;
//   $JUNCTION @ATTACH %j3(p) => @PLACE(82, 10) => %dot18;
//   $JUNCTION @ATTACH %j4(p) => @PLACE(124, 10) => %dot19;
//   $JUNCTION @ATTACH %j6(p) => @PLACE(118, 20) => %dot20;
//   $JUNCTION @ATTACH %j5(p) => @PLACE(124, 24) => %dot21;
//   $JUNCTION @ATTACH %j1(p) => @PLACE(26, 10) => %dot22;
//   $JUNCTION @ATTACH %j9(p) => @PLACE(60, 19) => %dot23;
//   %vdd1 @TEXT("\textbf{\textit{V}}_{\textbf{DD}}", dx=2, dy=1, size=1.5116, bold=false) => %power1;
//   $CANVAS_LABEL @ATTACH(bind="port") %power1(label);
//   %vdd2 @TEXT("\textbf{\textit{V}}_{\textbf{DD}}", dx=2, dy=1, size=1.5116, bold=false) => %power2;
//   $CANVAS_LABEL @ATTACH(bind="port") %power2(label);
//   %vdd3 @TEXT("\textbf{\textit{V}}_{\textbf{DD}}", dx=2, dy=1, size=1.5116, bold=false) => %power3;
//   $CANVAS_LABEL @ATTACH(bind="port") %power3(label);
//   %vdd4 @TEXT("\textbf{\textit{V}}_{\textbf{DD}}", dx=2, dy=1, size=1.5116, bold=false) => %power4;
//   $CANVAS_LABEL @ATTACH(bind="port") %power4(label);
//   %vdd5 @TEXT("\textbf{\textit{V}}_{\textbf{DD}}", dx=2, dy=1, size=1.5116, bold=false) => %power5;
//   $CANVAS_LABEL @ATTACH(bind="port") %power5(label);
//   %vdd6 @TEXT("\textbf{\textit{V}}_{\textbf{DD}}", dx=2, dy=1, size=1.5116, bold=false) => %power6;
//   $CANVAS_LABEL @ATTACH(bind="port") %power6(label);
//   %vdd7 @TEXT("\textbf{\textit{V}}_{\textbf{DD}}", dx=2, dy=1, size=1.5116, bold=false) => %power7;
//   $CANVAS_LABEL @ATTACH(bind="port") %power7(label);
//   %vdd8 @TEXT("\textbf{\textit{V}}_{\textbf{DD}}", dx=2, dy=1, size=1.5116, bold=false) => %power8;
//   $CANVAS_LABEL @ATTACH(bind="port") %power8(label);
//   %vdd9 @TEXT("\textbf{\textit{V}}_{\textbf{DD}}", dx=2, dy=1, size=1.5116, bold=false) => %power9;
//   $CANVAS_LABEL @ATTACH(bind="port") %power9(label);
//   %vdd10 @TEXT("\textbf{\textit{V}}_{\textbf{DD}}", dx=2, dy=1, size=1.5116, bold=false) => %power10;
//   $CANVAS_LABEL @ATTACH(bind="port") %power10(label);
//   #M13
//       @TEXT("\textbf{\textit{M}}_{\textbf{13}}", key="name", dx=-0.4, dy=-0.5, halign="end", valign="baseline", size=1.5116,
//       bold=false, textvisible=true);
//   $CANVAS_LABEL @ATTACH(bind="name") #M13::name(label);
//   #M14
//       @TEXT("\textbf{\textit{M}}_{\textbf{14}}", key="name", dx=0.4, dy=-0.5, halign="start", valign="baseline", size=1.5116,
//       bold=false, textvisible=true);
//   $CANVAS_LABEL @ATTACH(bind="name") #M14::name(label);
//   #M11
//       @TEXT("\textbf{\textit{M}}_{\textbf{11}}", key="name", dx=0.5, dy=-0.5, halign="start", valign="baseline", size=1.5116,
//       bold=false, textvisible=true);
//   $CANVAS_LABEL @ATTACH(bind="name") #M11::name(label);
//   #M12
//       @TEXT("\textbf{\textit{M}}_{\textbf{12}}", key="name", dx=-0.5, dy=-0.5, halign="end", valign="baseline", size=1.5116,
//       bold=false, textvisible=true);
//   $CANVAS_LABEL @ATTACH(bind="name") #M12::name(label);
//   #M15
//       @TEXT("\textbf{\textit{M}}_{\textbf{15}}", key="name", dx=0.5, dy=-0.5, halign="start", valign="baseline", size=1.5116,
//       bold=false, textvisible=true);
//   $CANVAS_LABEL @ATTACH(bind="name") #M15::name(label);
//   #M23
//       @TEXT("\textbf{\textit{M}}_{\textbf{23}}", key="name", dx=-0.4, dy=-0.5, halign="end", valign="baseline", size=1.5116,
//       bold=false, textvisible=true);
//   $CANVAS_LABEL @ATTACH(bind="name") #M23::name(label);
//   #M24
//       @TEXT("\textbf{\textit{M}}_{\textbf{24}}", key="name", dx=0.4, dy=-0.5, halign="start", valign="baseline", size=1.5116,
//       bold=false, textvisible=true);
//   $CANVAS_LABEL @ATTACH(bind="name") #M24::name(label);
//   #M21
//       @TEXT("\textbf{\textit{M}}_{\textbf{21}}", key="name", dx=0.5, dy=-0.5, halign="start", valign="baseline", size=1.5116,
//       bold=false, textvisible=true);
//   $CANVAS_LABEL @ATTACH(bind="name") #M21::name(label);
//   #M22
//       @TEXT("\textbf{\textit{M}}_{\textbf{22}}", key="name", dx=-0.5, dy=-0.5, halign="end", valign="baseline", size=1.5116,
//       bold=false, textvisible=true);
//   $CANVAS_LABEL @ATTACH(bind="name") #M22::name(label);
//   #M25
//       @TEXT("\textbf{\textit{M}}_{\textbf{25}}", key="name", dx=0.5, dy=-0.5, halign="start", valign="baseline", size=1.5116,
//       bold=false, textvisible=true);
//   $CANVAS_LABEL @ATTACH(bind="name") #M25::name(label);
//   #M33
//       @TEXT("\textbf{\textit{M}}_{\textbf{33}}", key="name", dx=-0.4, dy=-0.5, halign="end", valign="baseline", size=1.5116,
//       bold=false, textvisible=true);
//   $CANVAS_LABEL @ATTACH(bind="name") #M33::name(label);
//   #M34
//       @TEXT("\textbf{\textit{M}}_{\textbf{34}}", key="name", dx=0.4, dy=-0.5, halign="start", valign="baseline", size=1.5116,
//       bold=false, textvisible=true);
//   $CANVAS_LABEL @ATTACH(bind="name") #M34::name(label);
//   #M31
//       @TEXT("\textbf{\textit{M}}_{\textbf{31}}", key="name", dx=0.5, dy=-0.5, halign="start", valign="baseline", size=1.5116,
//       bold=false, textvisible=true);
//   $CANVAS_LABEL @ATTACH(bind="name") #M31::name(label);
//   #M32
//       @TEXT("\textbf{\textit{M}}_{\textbf{32}}", key="name", dx=-0.5, dy=-0.5, halign="end", valign="baseline", size=1.5116,
//       bold=false, textvisible=true);
//   $CANVAS_LABEL @ATTACH(bind="name") #M32::name(label);
//   #M35
//       @TEXT("\textbf{\textit{M}}_{\textbf{35}}", key="name", dx=0.5, dy=-0.5, halign="start", valign="baseline", size=1.5116,
//       bold=false, textvisible=true);
//   $CANVAS_LABEL @ATTACH(bind="name") #M35::name(label);
//   %port1
//       @TEXT("\textbf{\textit{v}}_{\textbf{op}}", key="netname", dx=-2, dy=-0.5, halign="end", valign="baseline", size=1.5116,
//       bold=false, textvisible=true);
//   $CANVAS_LABEL @ATTACH(bind="port") %port1::netname(label);
//   %port2
//       @TEXT("\textbf{\textit{v}}_{\textbf{on}}", key="netname", dx=2, dy=-0.5, halign="start", valign="baseline", size=1.5116,
//       bold=false, textvisible=true);
//   $CANVAS_LABEL @ATTACH(bind="port") %port2::netname(label);
//   %port3
//       @TEXT("\textbf{\textit{v}}_{\textbf{op}}", key="netname", dx=-2, dy=-0.5, halign="end", valign="baseline", size=1.5116,
//       bold=false, textvisible=true);
//   $CANVAS_LABEL @ATTACH(bind="port") %port3::netname(label);
//   %port4
//       @TEXT("\textbf{\textit{v}}_{\textbf{on}}", key="netname", dx=2, dy=-0.5, halign="start", valign="baseline", size=1.5116,
//       bold=false, textvisible=true);
//   $CANVAS_LABEL @ATTACH(bind="port") %port4::netname(label);
//   #MR2
//       @TEXT("\textbf{\textit{M}}_{\textbf{R2}}", key="name", dx=0.4, dy=-0.5, halign="start", valign="baseline", size=1.5116,
//       bold=false, textvisible=true);
//   $CANVAS_LABEL @ATTACH(bind="name") #MR2::name(label);
//   #MR1
//       @TEXT("\textbf{\textit{M}}_{\textbf{R1}}", key="name", dx=0.5, dy=-0.5, halign="start", valign="baseline", size=1.5116,
//       bold=false, textvisible=true);
//   $CANVAS_LABEL @ATTACH(bind="name") #MR1::name(label);
//   #MR3
//       @TEXT("\textbf{\textit{M}}_{\textbf{R3}}", key="name", dx=0.5, dy=-0.5, halign="start", valign="baseline", size=1.5116,
//       bold=false, textvisible=true);
//   $CANVAS_LABEL @ATTACH(bind="name") #MR3::name(label);
//   #MO3
//       @TEXT("\textbf{\textit{M}}_{\textbf{O3}}", key="name", dx=-0.4, dy=-0.5, halign="end", valign="baseline", size=1.5116,
//       bold=false, textvisible=true);
//   $CANVAS_LABEL @ATTACH(bind="name") #MO3::name(label);
//   #MO4
//       @TEXT("\textbf{\textit{M}}_{\textbf{O4}}", key="name", dx=0.4, dy=-0.5, halign="start", valign="baseline", size=1.5116,
//       bold=false, textvisible=true);
//   $CANVAS_LABEL @ATTACH(bind="name") #MO4::name(label);
//   #MO1
//       @TEXT("\textbf{\textit{M}}_{\textbf{O1}}", key="name", dx=0.5, dy=-0.5, halign="start", valign="baseline", size=1.5116,
//       bold=false, textvisible=true);
//   $CANVAS_LABEL @ATTACH(bind="name") #MO1::name(label);
//   #MO2
//       @TEXT("\textbf{\textit{M}}_{\textbf{O2}}", key="name", dx=-0.5, dy=-0.5, halign="end", valign="baseline", size=1.5116,
//       bold=false, textvisible=true);
//   $CANVAS_LABEL @ATTACH(bind="name") #MO2::name(label);
//   %port5
//       @TEXT("\textbf{\textit{v}}_{\textbf{ref}}", key="netname", dx=2, dy=-0.5, halign="start", valign="baseline", size=1.5116,
//       bold=false, textvisible=true);
//   $CANVAS_LABEL @ATTACH(bind="port") %port5::netname(label);
//   #MO5
//       @TEXT("\textbf{\textit{M}}_{\textbf{O5}}", key="name", dx=0.5, dy=-0.5, halign="start", valign="baseline", size=1.5116,
//       bold=false, textvisible=true);
//   $CANVAS_LABEL @ATTACH(bind="name") #MO5::name(label);
//   #Cc
//       @TEXT("\textbf{\textit{C}}_{\textbf{c}}", key="name", dx=1.2, dy=-0.5, halign="start", valign="baseline", size=1.5116,
//       bold=false, textvisible=true);
//   $CANVAS_LABEL @ATTACH(bind="name") #Cc::name(label);
//   #Cc
//       @TEXT("\textbf{0.2pF}", key="value", dx=1.2, dy=-2.5, halign="start", valign="baseline", size=1.5116, bold=false,
//       textvisible=true);
//   $CANVAS_LABEL @ATTACH(bind="value") #Cc::value(label);
//   %port6
//       @TEXT("\textbf{\textit{v}}_{\textbf{ctrl}}", key="netname", dx=2, dy=-0.5, halign="start", valign="baseline", size=1.5116,
//       bold=false, textvisible=true);
//   $CANVAS_LABEL @ATTACH(bind="port") %port6::netname(label);
//   %wire5 @TEXT("\textbf{\textit{a1}}", halign="middle", size=1.5116, bold=false) => @PLACE(66, 14.4) => %label1;
//   $CANVAS_LABEL @ATTACH(bind="net") %label1(label);
//   %wire6 @TEXT("\textbf{\textit{a2}}", halign="middle", size=1.5116, bold=false) => @PLACE(94, 14.4) => %label2;
//   $CANVAS_LABEL @ATTACH(bind="net") %label2(label);
//   %wire1 @TEXT("\textbf{\textit{a1}}", size=1.5116, bold=false) => @PLACE(20.8, 19.6) => %label3;
//   $CANVAS_LABEL @ATTACH(bind="net") %label3(label);
//   %wire2 @TEXT("\textbf{\textit{a2}}", size=1.5116, bold=false) => @PLACE(48.8, 19.6) => %label4;
//   $CANVAS_LABEL @ATTACH(bind="net") %label4(label);
//   %wire4 @TEXT("\textbf{\textit{v}}_{\textbf{bp}}", halign="middle", size=1.5116, bold=false) => @PLACE(59.6, 33) => %label5;
//   $CANVAS_LABEL @ATTACH(bind="net") %label5(label);
//   %wire3 @TEXT("\textbf{\textit{v}}_{\textbf{rep}}", halign="middle", size=1.5116, bold=false) => @PLACE(109.6, 20) => %label6;
//   $CANVAS_LABEL @ATTACH(bind="net") %label6(label);
//   %vdd1 @TEXT("${p}", key="netname", textvisible=false);
//   %vdd2 @TEXT("${p}", key="netname", textvisible=false);
//   %vdd3 @TEXT("${p}", key="netname", textvisible=false);
//   %vdd4 @TEXT("${p}", key="netname", textvisible=false);
//   %vdd5 @TEXT("${p}", key="netname", textvisible=false);
//   %vdd6 @TEXT("${p}", key="netname", textvisible=false);
//   %vdd7 @TEXT("${p}", key="netname", textvisible=false);
//   %vdd8 @TEXT("${p}", key="netname", textvisible=false);
//   %vdd9 @TEXT("${p}", key="netname", textvisible=false);
//   %vdd10 @TEXT("${p}", key="netname", textvisible=false)
// }
ends ring_vco_replica
