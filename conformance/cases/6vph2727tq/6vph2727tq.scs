simulator lang=spectre
// @RNL(type="header") {
//   @VERSION("0.4");
//   @USE-PACKAGE(name="rnl-std-style", version="0.4");
//   @USE-PACKAGE(name="rnl-std-basic", version="0.4");
//   @USE-PACKAGE(name="rnl-std-semiconductors", version="0.4");
//   @USE-PACKAGE(name="rnl-std-no-labels", version="0.4");
//   @USE-PACKAGE(name="analog-canvas-extensions", version="0.7");
//   @USE-PACKAGE(name="rnl-std-logic", version="0.4")
// }

// Ideal inverter: switches at V(VDD,VSS)/2; vt sets the step width, td the delay
subckt inverter (A Y VDD VSS)
parameters vt=10m td=10p
BhA (hA 0) bsource v=0.5*(1+tanh((v(A,VSS)-0.5*v(VDD,VSS))/vt))
Bf (nfn VSS) bsource v=v(VDD,VSS)*(1-v(hA))
Rd (nfn ndl) resistor r=1k
Cd (ndl VSS) capacitor c=td/1000
BY (Y VSS) bsource v=v(ndl,VSS)
ends inverter

subckt dut (VDD VSS X3 X2 X1 X0 X7 X6 X5 X4 X11 X10 X9 X8 CLK CLKB D Q)
M1 (X0 X3 VDD VDD) sky130_fd_pr__pfet_01v8 l=0.15 w=1 nf=1 m=1
M10 (X1 X2 VSS VSS) sky130_fd_pr__nfet_01v8 l=0.15 w=1 nf=1 m=1
M11 (X2 X1 VSS VSS) sky130_fd_pr__nfet_01v8 l=0.15 w=1 nf=1 m=1
M12 (net3 X2 VSS VSS) sky130_fd_pr__nfet_01v8 l=0.15 w=1 nf=1 m=1
M13 (X4 X7 VDD VDD) sky130_fd_pr__pfet_01v8 l=0.15 w=1 nf=1 m=1
M14 (net24 X4 VDD VDD) sky130_fd_pr__pfet_01v8 l=0.15 w=1 nf=1 m=1
M15 (net1 X7 VDD VDD) sky130_fd_pr__pfet_01v8 l=0.15 w=1 nf=1 m=1
M16 (X7 X4 VDD VDD) sky130_fd_pr__pfet_01v8 l=0.15 w=1 nf=1 m=1
M17 (net7 X6 X4 VDD) sky130_fd_pr__pfet_01v8 l=0.15 w=1 nf=1 m=1
M18 (X5 X6 net24 VDD) sky130_fd_pr__pfet_01v8 l=0.15 w=1 nf=1 m=1
M19 (X6 X5 net1 VDD) sky130_fd_pr__pfet_01v8 l=0.15 w=1 nf=1 m=1
M2 (net23 X0 VDD VDD) sky130_fd_pr__pfet_01v8 l=0.15 w=1 nf=1 m=1
M20 (net4 X5 X7 VDD) sky130_fd_pr__pfet_01v8 l=0.15 w=1 nf=1 m=1
M21 (net7 X5 VSS VSS) sky130_fd_pr__nfet_01v8 l=0.15 w=1 nf=1 m=1
M22 (X5 X6 VSS VSS) sky130_fd_pr__nfet_01v8 l=0.15 w=1 nf=1 m=1
M23 (X6 X5 VSS VSS) sky130_fd_pr__nfet_01v8 l=0.15 w=1 nf=1 m=1
M24 (net4 X6 VSS VSS) sky130_fd_pr__nfet_01v8 l=0.15 w=1 nf=1 m=1
M25 (X8 X11 VDD VDD) sky130_fd_pr__pfet_01v8 l=0.15 w=1 nf=1 m=1
M26 (net25 X8 VDD VDD) sky130_fd_pr__pfet_01v8 l=0.15 w=1 nf=1 m=1
M27 (net2 X11 VDD VDD) sky130_fd_pr__pfet_01v8 l=0.15 w=1 nf=1 m=1
M28 (X11 X8 VDD VDD) sky130_fd_pr__pfet_01v8 l=0.15 w=1 nf=1 m=1
M29 (net8 X10 X8 VDD) sky130_fd_pr__pfet_01v8 l=0.15 w=1 nf=1 m=1
M3 (net0 X3 VDD VDD) sky130_fd_pr__pfet_01v8 l=0.15 w=1 nf=1 m=1
M30 (X9 X10 net25 VDD) sky130_fd_pr__pfet_01v8 l=0.15 w=1 nf=1 m=1
M31 (X10 X9 net2 VDD) sky130_fd_pr__pfet_01v8 l=0.15 w=1 nf=1 m=1
M32 (net5 X9 X11 VDD) sky130_fd_pr__pfet_01v8 l=0.15 w=1 nf=1 m=1
M33 (net8 X9 VSS VSS) sky130_fd_pr__nfet_01v8 l=0.15 w=1 nf=1 m=1
M34 (X9 X10 VSS VSS) sky130_fd_pr__nfet_01v8 l=0.15 w=1 nf=1 m=1
M35 (X10 X9 VSS VSS) sky130_fd_pr__nfet_01v8 l=0.15 w=1 nf=1 m=1
M36 (net5 X10 VSS VSS) sky130_fd_pr__nfet_01v8 l=0.15 w=1 nf=1 m=1
M37 (Q CLK D VSS) sky130_fd_pr__nfet_01v8 l=0.15 w=1 nf=1 m=1
M38 (Q CLKB D VDD) sky130_fd_pr__pfet_01v8 l=0.15 w=1 nf=1 m=1
M39 (X0 CLK D VSS) sky130_fd_pr__nfet_01v8 l=0.15 w=1 nf=1 m=1
M4 (X3 X0 VDD VDD) sky130_fd_pr__pfet_01v8 l=0.15 w=1 nf=1 m=1
M40 (X1 CLK DN VSS) sky130_fd_pr__nfet_01v8 l=0.15 w=1 nf=1 m=1
M41 (X2 CLK D VSS) sky130_fd_pr__nfet_01v8 l=0.15 w=1 nf=1 m=1
M42 (X3 CLK D VSS) sky130_fd_pr__nfet_01v8 l=0.15 w=1 nf=1 m=1
M43 (X4 CLK D VSS) sky130_fd_pr__nfet_01v8 l=0.15 w=1 nf=1 m=1
M44 (X5 CLK D VSS) sky130_fd_pr__nfet_01v8 l=0.15 w=1 nf=1 m=1
M45 (X6 CLK D VSS) sky130_fd_pr__nfet_01v8 l=0.15 w=1 nf=1 m=1
M46 (X7 CLK D VSS) sky130_fd_pr__nfet_01v8 l=0.15 w=1 nf=1 m=1
M47 (X8 CLK D VSS) sky130_fd_pr__nfet_01v8 l=0.15 w=1 nf=1 m=1
M48 (X9 CLK D VSS) sky130_fd_pr__nfet_01v8 l=0.15 w=1 nf=1 m=1
M49 (X10 CLK D VSS) sky130_fd_pr__nfet_01v8 l=0.15 w=1 nf=1 m=1
M5 (net6 X2 X0 VDD) sky130_fd_pr__pfet_01v8 l=0.15 w=1 nf=1 m=1
M50 (X11 CLK DN VSS) sky130_fd_pr__nfet_01v8 l=0.15 w=1 nf=1 m=1
M51 (net9 X3 VDD VDD) sky130_fd_pr__pfet_01v8 l=0.15 w=1 nf=1 m=1
M52 (X12 X5 net9 VDD) sky130_fd_pr__pfet_01v8 l=0.15 w=1 nf=1 m=1
M53 (X12 X5 net14 VSS) sky130_fd_pr__nfet_01v8 l=0.15 w=1 nf=1 m=1
M54 (net14 X3 VSS VSS) sky130_fd_pr__nfet_01v8 l=0.15 w=1 nf=1 m=1
M55 (net10 X7 VDD VDD) sky130_fd_pr__pfet_01v8 l=0.15 w=1 nf=1 m=1
M56 (X13 X9 net10 VDD) sky130_fd_pr__pfet_01v8 l=0.15 w=1 nf=1 m=1
M57 (X13 X9 net15 VSS) sky130_fd_pr__nfet_01v8 l=0.15 w=1 nf=1 m=1
M58 (net15 X7 VSS VSS) sky130_fd_pr__nfet_01v8 l=0.15 w=1 nf=1 m=1
M59 (net11 X11 VDD VDD) sky130_fd_pr__pfet_01v8 l=0.15 w=1 nf=1 m=1
M6 (X1 X2 net23 VDD) sky130_fd_pr__pfet_01v8 l=0.15 w=1 nf=1 m=1
M60 (X14 X1 net11 VDD) sky130_fd_pr__pfet_01v8 l=0.15 w=1 nf=1 m=1
M61 (X14 X1 net16 VSS) sky130_fd_pr__nfet_01v8 l=0.15 w=1 nf=1 m=1
M62 (net16 X11 VSS VSS) sky130_fd_pr__nfet_01v8 l=0.15 w=1 nf=1 m=1
M63 (net12 X12 VDD VDD) sky130_fd_pr__pfet_01v8 l=0.15 w=1 nf=1 m=1
M64 (X15 X13 net12 VDD) sky130_fd_pr__pfet_01v8 l=0.15 w=1 nf=1 m=1
M65 (X15 X13 net17 VSS) sky130_fd_pr__nfet_01v8 l=0.15 w=1 nf=1 m=1
M66 (net17 X12 VSS VSS) sky130_fd_pr__nfet_01v8 l=0.15 w=1 nf=1 m=1
M67 (net13 X13 VDD VDD) sky130_fd_pr__pfet_01v8 l=0.15 w=1 nf=1 m=1
M68 (X16 X14 net13 VDD) sky130_fd_pr__pfet_01v8 l=0.15 w=1 nf=1 m=1
M69 (X16 X14 net18 VSS) sky130_fd_pr__nfet_01v8 l=0.15 w=1 nf=1 m=1
M7 (X2 X1 net0 VDD) sky130_fd_pr__pfet_01v8 l=0.15 w=1 nf=1 m=1
M70 (net18 X13 VSS VSS) sky130_fd_pr__nfet_01v8 l=0.15 w=1 nf=1 m=1
M71 (net19 X15 VDD VDD) sky130_fd_pr__pfet_01v8 l=0.15 w=1 nf=1 m=1
M72 (net20 X16 net19 VDD) sky130_fd_pr__pfet_01v8 l=0.15 w=1 nf=1 m=1
M73 (Q CLK net20 VDD) sky130_fd_pr__pfet_01v8 l=0.15 w=1 nf=1 m=1
M74 (Q CLKB net21 VSS) sky130_fd_pr__nfet_01v8 l=0.15 w=1 nf=1 m=1
M75 (net21 X16 net22 VSS) sky130_fd_pr__nfet_01v8 l=0.15 w=1 nf=1 m=1
M76 (net22 X15 VSS VSS) sky130_fd_pr__nfet_01v8 l=0.15 w=1 nf=1 m=1
M8 (net3 X1 X3 VDD) sky130_fd_pr__pfet_01v8 l=0.15 w=1 nf=1 m=1
M9 (net6 X1 VSS VSS) sky130_fd_pr__nfet_01v8 l=0.15 w=1 nf=1 m=1
X1 (D DN VDD VSS) inverter td=10p vt=10m
X2 (CLK CLKB VDD VSS) inverter td=10p vt=10m
// @RNL(author="analog-canvas") {
//   %dut_SYMBOL = @DEFINE-SYMBOL(box=[-5, -11, 5, 11]) {
//     (-5, 6) @PIN(terminal="X3", label="\textbf{\textit{X}}_{\textbf{3}}", direction="left");
//     (-5, -2) @PIN(terminal="X2", label="\textbf{\textit{X}}_{\textbf{2}}", direction="left");
//     (-5, -6) @PIN(terminal="X1", label="\textbf{\textit{X}}_{\textbf{1}}", direction="left");
//     (-5, 4) @PIN(terminal="X0", label="\textbf{\textit{X}}_{\textbf{0}}", direction="left");
//     (0, 11) @PIN(terminal="VDD", label="\textbf{\textit{V}}_{\textbf{DD}}", direction="up");
//     (-5, 2) @PIN(terminal="X7", label="\textbf{\textit{X}}_{\textbf{7}}", direction="left");
//     (-5, -4) @PIN(terminal="X6", label="\textbf{\textit{X}}_{\textbf{6}}", direction="left");
//     (-5, -8) @PIN(terminal="X5", label="\textbf{\textit{X}}_{\textbf{5}}", direction="left");
//     (-5, 0) @PIN(terminal="X4", label="\textbf{\textit{X}}_{\textbf{4}}", direction="left");
//     (5, 6) @PIN(terminal="X11", label="\textbf{\textit{X}}_{\textbf{11}}", direction="right");
//     (5, 2) @PIN(terminal="X10", label="\textbf{\textit{X}}_{\textbf{10}}", direction="right");
//     (5, 0) @PIN(terminal="X9", label="\textbf{\textit{X}}_{\textbf{9}}", direction="right");
//     (5, 4) @PIN(terminal="X8", label="\textbf{\textit{X}}_{\textbf{8}}", direction="right");
//     (5, -2) @PIN(terminal="CLK", label="\textbf{\textit{CLK}}", direction="right");
//     (5, -8) @PIN(terminal="CLKB", label="\textbf{\textit{CLKB}}", direction="right");
//     (5, -4) @PIN(terminal="D", label="\textbf{\textit{D}}", direction="right");
//     (5, -6) @PIN(terminal="Q", label="\textbf{\textit{Q}}", direction="right");
//     (0, 0) @RECTANGLE(width=8, height=20);
//     @LINE {(-5, 6) (-4, 6)};
//     @LINE {(-5, -2) (-4, -2)};
//     @LINE {(-5, -6) (-4, -6)};
//     @LINE {(-5, 4) (-4, 4)};
//     @LINE {(0, 11) (0, 10)};
//     @LINE {(-5, 2) (-4, 2)};
//     @LINE {(-5, -4) (-4, -4)};
//     @LINE {(-5, -8) (-4, -8)};
//     @LINE {(-5, 0) (-4, 0)};
//     @LINE {(5, 6) (4, 6)};
//     @LINE {(5, 2) (4, 2)};
//     @LINE {(5, 0) (4, 0)};
//     @LINE {(5, 4) (4, 4)};
//     @LINE {(5, -2) (4, -2)};
//     @LINE {(5, -8) (4, -8)};
//     @LINE {(5, -4) (4, -4)};
//     @LINE {(5, -6) (4, -6)}
//   };
//   # @SET-SYMBOL %dut_SYMBOL;
//   $CANVAS_TYPESETTING @ATTACH(subscript_italic=false) #(level);
//   #M1 @SET-SYMBOL(terminals=[[1, "d"], [2, "g"], [3, "s"]]) $PMOS => @PLACE(38, -7) => @ORIENT("R0");
//   #M2 @SET-SYMBOL(terminals=[[1, "d"], [2, "g"], [3, "s"]]) $PMOS => @PLACE(48, -7) => @ORIENT("R0");
//   #M3 @SET-SYMBOL(terminals=[[1, "d"], [2, "g"], [3, "s"]]) $PMOS => @PLACE(58, -7) => @ORIENT("R0");
//   #M4 @SET-SYMBOL(terminals=[[1, "d"], [2, "g"], [3, "s"]]) $PMOS => @PLACE(69, -7) => @ORIENT("R0");
//   #M5 @SET-SYMBOL(terminals=[[1, "d"], [2, "g"], [3, "s"]]) $PMOS => @PLACE(38, -13) => @ORIENT("R0");
//   #M6 @SET-SYMBOL(terminals=[[1, "d"], [2, "g"], [3, "s"]]) $PMOS => @PLACE(48, -13) => @ORIENT("R0");
//   #M7 @SET-SYMBOL(terminals=[[1, "d"], [2, "g"], [3, "s"]]) $PMOS => @PLACE(58, -13) => @ORIENT("R0");
//   #M8 @SET-SYMBOL(terminals=[[1, "d"], [2, "g"], [3, "s"]]) $PMOS => @PLACE(69, -13) => @ORIENT("R0");
//   #M9 @SET-SYMBOL(terminals=[[1, "d"], [2, "g"], [3, "s"]]) $NMOS => @PLACE(38, -19) => @ORIENT("R0");
//   #M10 @SET-SYMBOL(terminals=[[1, "d"], [2, "g"], [3, "s"]]) $NMOS => @PLACE(48, -19) => @ORIENT("R0");
//   #M11 @SET-SYMBOL(terminals=[[1, "d"], [2, "g"], [3, "s"]]) $NMOS => @PLACE(58, -19) => @ORIENT("R0");
//   #M12 @SET-SYMBOL(terminals=[[1, "d"], [2, "g"], [3, "s"]]) $NMOS => @PLACE(69, -19) => @ORIENT("R0");
//   $IO_PORT @ATTACH &X3(p) => @SET-SYMBOL $IO_PORT_SYMBOL => @PLACE(35, -7) => @ORIENT("R0") => %port1;
//   $IO_PORT @ATTACH &X2(p) => @SET-SYMBOL $IO_PORT_SYMBOL => @PLACE(35, -13) => @ORIENT("R0") => %port2;
//   $IO_PORT @ATTACH &X1(p) => @SET-SYMBOL $IO_PORT_SYMBOL => @PLACE(35, -19) => @ORIENT("R0") => %port3;
//   $IO_PORT @ATTACH &X2(p) => @SET-SYMBOL $IO_PORT_SYMBOL => @PLACE(45, -19) => @ORIENT("R0") => %port4;
//   $IO_PORT @ATTACH &X2(p) => @SET-SYMBOL $IO_PORT_SYMBOL => @PLACE(45, -13) => @ORIENT("R0") => %port5;
//   $IO_PORT @ATTACH &X0(p) => @SET-SYMBOL $IO_PORT_SYMBOL => @PLACE(45, -7) => @ORIENT("R0") => %port6;
//   $IO_PORT @ATTACH &X3(p) => @SET-SYMBOL $IO_PORT_SYMBOL => @PLACE(55, -7) => @ORIENT("R0") => %port7;
//   $IO_PORT @ATTACH &X1(p) => @SET-SYMBOL $IO_PORT_SYMBOL => @PLACE(55, -13) => @ORIENT("R0") => %port8;
//   $IO_PORT @ATTACH &X1(p) => @SET-SYMBOL $IO_PORT_SYMBOL => @PLACE(55, -19) => @ORIENT("R0") => %port9;
//   $IO_PORT @ATTACH &X0(p) => @SET-SYMBOL $IO_PORT_SYMBOL => @PLACE(66, -7) => @ORIENT("R0") => %port10;
//   $IO_PORT @ATTACH &X1(p) => @SET-SYMBOL $IO_PORT_SYMBOL => @PLACE(66, -13) => @ORIENT("R0") => %port11;
//   $IO_PORT @ATTACH &X2(p) => @SET-SYMBOL $IO_PORT_SYMBOL => @PLACE(66, -19) => @ORIENT("R0") => %port12;
//   $SUPPLY @ATTACH &VDD(p) => @SET-SYMBOL $SUPPLY_SYMBOL => @PLACE(53, -4) => @ORIENT("R0") => %vdd1;
//   $GROUND @ATTACH &VSS(p) => @SET-SYMBOL $GROUND_SYMBOL => @PLACE(53, -22) => @ORIENT("R0") => %gnd1;
//   #M13 @SET-SYMBOL(terminals=[[1, "d"], [2, "g"], [3, "s"]]) $PMOS => @PLACE(81, -7) => @ORIENT("R0");
//   #M14 @SET-SYMBOL(terminals=[[1, "d"], [2, "g"], [3, "s"]]) $PMOS => @PLACE(91, -7) => @ORIENT("R0");
//   #M15 @SET-SYMBOL(terminals=[[1, "d"], [2, "g"], [3, "s"]]) $PMOS => @PLACE(101, -7) => @ORIENT("R0");
//   #M16 @SET-SYMBOL(terminals=[[1, "d"], [2, "g"], [3, "s"]]) $PMOS => @PLACE(112, -7) => @ORIENT("R0");
//   #M17 @SET-SYMBOL(terminals=[[1, "d"], [2, "g"], [3, "s"]]) $PMOS => @PLACE(81, -13) => @ORIENT("R0");
//   #M18 @SET-SYMBOL(terminals=[[1, "d"], [2, "g"], [3, "s"]]) $PMOS => @PLACE(91, -13) => @ORIENT("R0");
//   #M19 @SET-SYMBOL(terminals=[[1, "d"], [2, "g"], [3, "s"]]) $PMOS => @PLACE(101, -13) => @ORIENT("R0");
//   #M20 @SET-SYMBOL(terminals=[[1, "d"], [2, "g"], [3, "s"]]) $PMOS => @PLACE(112, -13) => @ORIENT("R0");
//   #M21 @SET-SYMBOL(terminals=[[1, "d"], [2, "g"], [3, "s"]]) $NMOS => @PLACE(81, -19) => @ORIENT("R0");
//   #M22 @SET-SYMBOL(terminals=[[1, "d"], [2, "g"], [3, "s"]]) $NMOS => @PLACE(91, -19) => @ORIENT("R0");
//   #M23 @SET-SYMBOL(terminals=[[1, "d"], [2, "g"], [3, "s"]]) $NMOS => @PLACE(101, -19) => @ORIENT("R0");
//   #M24 @SET-SYMBOL(terminals=[[1, "d"], [2, "g"], [3, "s"]]) $NMOS => @PLACE(112, -19) => @ORIENT("R0");
//   $IO_PORT @ATTACH &X7(p) => @SET-SYMBOL $IO_PORT_SYMBOL => @PLACE(78, -7) => @ORIENT("R0") => %port13;
//   $IO_PORT @ATTACH &X6(p) => @SET-SYMBOL $IO_PORT_SYMBOL => @PLACE(78, -13) => @ORIENT("R0") => %port14;
//   $IO_PORT @ATTACH &X5(p) => @SET-SYMBOL $IO_PORT_SYMBOL => @PLACE(78, -19) => @ORIENT("R0") => %port15;
//   $IO_PORT @ATTACH &X6(p) => @SET-SYMBOL $IO_PORT_SYMBOL => @PLACE(88, -19) => @ORIENT("R0") => %port16;
//   $IO_PORT @ATTACH &X6(p) => @SET-SYMBOL $IO_PORT_SYMBOL => @PLACE(88, -13) => @ORIENT("R0") => %port17;
//   $IO_PORT @ATTACH &X4(p) => @SET-SYMBOL $IO_PORT_SYMBOL => @PLACE(88, -7) => @ORIENT("R0") => %port18;
//   $IO_PORT @ATTACH &X4(p) => @SET-SYMBOL $IO_PORT_SYMBOL => @PLACE(109, -7) => @ORIENT("R0") => %port19;
//   $IO_PORT @ATTACH &X5(p) => @SET-SYMBOL $IO_PORT_SYMBOL => @PLACE(109, -13) => @ORIENT("R0") => %port20;
//   $IO_PORT @ATTACH &X6(p) => @SET-SYMBOL $IO_PORT_SYMBOL => @PLACE(109, -19) => @ORIENT("R0") => %port21;
//   $SUPPLY @ATTACH &VDD(p) => @SET-SYMBOL $SUPPLY_SYMBOL => @PLACE(96, -4) => @ORIENT("R0") => %vdd2;
//   $GROUND @ATTACH &VSS(p) => @SET-SYMBOL $GROUND_SYMBOL => @PLACE(96, -22) => @ORIENT("R0") => %gnd2;
//   #M25 @SET-SYMBOL(terminals=[[1, "d"], [2, "g"], [3, "s"]]) $PMOS => @PLACE(123, -7) => @ORIENT("R0");
//   #M26 @SET-SYMBOL(terminals=[[1, "d"], [2, "g"], [3, "s"]]) $PMOS => @PLACE(133, -7) => @ORIENT("R0");
//   #M27 @SET-SYMBOL(terminals=[[1, "d"], [2, "g"], [3, "s"]]) $PMOS => @PLACE(143, -7) => @ORIENT("R0");
//   #M28 @SET-SYMBOL(terminals=[[1, "d"], [2, "g"], [3, "s"]]) $PMOS => @PLACE(154, -7) => @ORIENT("R0");
//   #M29 @SET-SYMBOL(terminals=[[1, "d"], [2, "g"], [3, "s"]]) $PMOS => @PLACE(123, -13) => @ORIENT("R0");
//   #M30 @SET-SYMBOL(terminals=[[1, "d"], [2, "g"], [3, "s"]]) $PMOS => @PLACE(133, -13) => @ORIENT("R0");
//   #M31 @SET-SYMBOL(terminals=[[1, "d"], [2, "g"], [3, "s"]]) $PMOS => @PLACE(143, -13) => @ORIENT("R0");
//   #M32 @SET-SYMBOL(terminals=[[1, "d"], [2, "g"], [3, "s"]]) $PMOS => @PLACE(154, -13) => @ORIENT("R0");
//   #M33 @SET-SYMBOL(terminals=[[1, "d"], [2, "g"], [3, "s"]]) $NMOS => @PLACE(123, -19) => @ORIENT("R0");
//   #M34 @SET-SYMBOL(terminals=[[1, "d"], [2, "g"], [3, "s"]]) $NMOS => @PLACE(133, -19) => @ORIENT("R0");
//   #M35 @SET-SYMBOL(terminals=[[1, "d"], [2, "g"], [3, "s"]]) $NMOS => @PLACE(143, -19) => @ORIENT("R0");
//   #M36 @SET-SYMBOL(terminals=[[1, "d"], [2, "g"], [3, "s"]]) $NMOS => @PLACE(154, -19) => @ORIENT("R0");
//   $IO_PORT @ATTACH &X11(p) => @SET-SYMBOL $IO_PORT_SYMBOL => @PLACE(120, -7) => @ORIENT("R0") => %port22;
//   $IO_PORT @ATTACH &X10(p) => @SET-SYMBOL $IO_PORT_SYMBOL => @PLACE(120, -13) => @ORIENT("R0") => %port23;
//   $IO_PORT @ATTACH &X9(p) => @SET-SYMBOL $IO_PORT_SYMBOL => @PLACE(120, -19) => @ORIENT("R0") => %port24;
//   $IO_PORT @ATTACH &X10(p) => @SET-SYMBOL $IO_PORT_SYMBOL => @PLACE(130, -19) => @ORIENT("R0") => %port25;
//   $IO_PORT @ATTACH &X10(p) => @SET-SYMBOL $IO_PORT_SYMBOL => @PLACE(130, -13) => @ORIENT("R0") => %port26;
//   $IO_PORT @ATTACH &X8(p) => @SET-SYMBOL $IO_PORT_SYMBOL => @PLACE(130, -7) => @ORIENT("R0") => %port27;
//   $SUPPLY @ATTACH &VDD(p) => @SET-SYMBOL $SUPPLY_SYMBOL => @PLACE(138, -4) => @ORIENT("R0") => %vdd3;
//   $GROUND @ATTACH &VSS(p) => @SET-SYMBOL $GROUND_SYMBOL => @PLACE(138, -22) => @ORIENT("R0") => %gnd3;
//   $IO_PORT @ATTACH &X7(p) => @SET-SYMBOL $IO_PORT_SYMBOL => @PLACE(98, -7) => @ORIENT("R0") => %port28;
//   $IO_PORT @ATTACH &X5(p) => @SET-SYMBOL $IO_PORT_SYMBOL => @PLACE(98, -19) => @ORIENT("R0") => %port29;
//   $IO_PORT @ATTACH &X5(p) => @SET-SYMBOL $IO_PORT_SYMBOL => @PLACE(98, -13) => @ORIENT("R0") => %port30;
//   $IO_PORT @ATTACH &X11(p) => @SET-SYMBOL $IO_PORT_SYMBOL => @PLACE(140, -7) => @ORIENT("R0") => %port31;
//   $IO_PORT @ATTACH &X9(p) => @SET-SYMBOL $IO_PORT_SYMBOL => @PLACE(140, -13) => @ORIENT("R0") => %port32;
//   $IO_PORT @ATTACH &X9(p) => @SET-SYMBOL $IO_PORT_SYMBOL => @PLACE(140, -19) => @ORIENT("R0") => %port33;
//   $IO_PORT @ATTACH &X8(p) => @SET-SYMBOL $IO_PORT_SYMBOL => @PLACE(151, -7) => @ORIENT("R0") => %port34;
//   $IO_PORT @ATTACH &X9(p) => @SET-SYMBOL $IO_PORT_SYMBOL => @PLACE(151, -13) => @ORIENT("R0") => %port35;
//   $IO_PORT @ATTACH &X10(p) => @SET-SYMBOL $IO_PORT_SYMBOL => @PLACE(151, -19) => @ORIENT("R0") => %port36;
//   #M37 @SET-SYMBOL(terminals=[[1, "d"], [2, "g"], [3, "s"]]) $NMOS => @PLACE(112, -51) => @ORIENT("R270");
//   #M38 @SET-SYMBOL(terminals=[[1, "d"], [2, "g"], [3, "s"]]) $PMOS => @PLACE(112, -53) => @ORIENT("R90");
//   $IO_PORT @ATTACH &CLK(p) => @SET-SYMBOL $IO_PORT_SYMBOL => @PLACE(112, -48) => @ORIENT("R270") => %port37;
//   $IO_PORT @ATTACH &CLKB(p) => @SET-SYMBOL $IO_PORT_SYMBOL => @PLACE(112, -56) => @ORIENT("R90") => %port38;
//   $IO_PORT @ATTACH &D(p) => @SET-SYMBOL $IO_PORT_SYMBOL => @PLACE(106, -52) => @ORIENT("R0") => %port39;
//   $IO_PORT @ATTACH &Q(p) => @SET-SYMBOL $IO_PORT_SYMBOL => @PLACE(118, -52) => @ORIENT("R180") => %port40;
//   #M39 @SET-SYMBOL(terminals=[[1, "d"], [2, "g"], [3, "s"]]) $NMOS => @PLACE(39, -35) => @ORIENT("R0");
//   #M40 @SET-SYMBOL(terminals=[[1, "d"], [2, "g"], [3, "s"]]) $NMOS => @PLACE(46, -35) => @ORIENT("R0");
//   #M41 @SET-SYMBOL(terminals=[[1, "d"], [2, "g"], [3, "s"]]) $NMOS => @PLACE(53, -35) => @ORIENT("R0");
//   #M42 @SET-SYMBOL(terminals=[[1, "d"], [2, "g"], [3, "s"]]) $NMOS => @PLACE(60, -35) => @ORIENT("R0");
//   #M43 @SET-SYMBOL(terminals=[[1, "d"], [2, "g"], [3, "s"]]) $NMOS => @PLACE(67, -35) => @ORIENT("R0");
//   #M44 @SET-SYMBOL(terminals=[[1, "d"], [2, "g"], [3, "s"]]) $NMOS => @PLACE(74, -35) => @ORIENT("R0");
//   #M45 @SET-SYMBOL(terminals=[[1, "d"], [2, "g"], [3, "s"]]) $NMOS => @PLACE(81, -35) => @ORIENT("R0");
//   #M46 @SET-SYMBOL(terminals=[[1, "d"], [2, "g"], [3, "s"]]) $NMOS => @PLACE(88, -35) => @ORIENT("R0");
//   #M47 @SET-SYMBOL(terminals=[[1, "d"], [2, "g"], [3, "s"]]) $NMOS => @PLACE(95, -35) => @ORIENT("R0");
//   #M48 @SET-SYMBOL(terminals=[[1, "d"], [2, "g"], [3, "s"]]) $NMOS => @PLACE(102, -35) => @ORIENT("R0");
//   #M49 @SET-SYMBOL(terminals=[[1, "d"], [2, "g"], [3, "s"]]) $NMOS => @PLACE(109, -35) => @ORIENT("R0");
//   #M50 @SET-SYMBOL(terminals=[[1, "d"], [2, "g"], [3, "s"]]) $NMOS => @PLACE(116, -35) => @ORIENT("R0");
//   $IO_PORT @ATTACH &CLK(p) => @SET-SYMBOL $IO_PORT_SYMBOL => @PLACE(36, -35) => @ORIENT("R0") => %port41;
//   #X1 @SET-SYMBOL(terminals=[[1, "a"], [2, "y"]]) $INVERTER => @PLACE(113, -63) => @ORIENT("R0");
//   #X2 @SET-SYMBOL(terminals=[[1, "a"], [2, "y"]]) $INVERTER => @PLACE(113, -71) => @ORIENT("R0");
//   #M51 @SET-SYMBOL(terminals=[[1, "d"], [2, "g"], [3, "s"]]) $PMOS => @PLACE(39, -51) => @ORIENT("R0");
//   #M52 @SET-SYMBOL(terminals=[[1, "d"], [2, "g"], [3, "s"]]) $PMOS => @PLACE(39, -57) => @ORIENT("R0");
//   #M53 @SET-SYMBOL(terminals=[[1, "d"], [2, "g"], [3, "s"]]) $NMOS => @PLACE(39, -63) => @ORIENT("R0");
//   #M54 @SET-SYMBOL(terminals=[[1, "d"], [2, "g"], [3, "s"]]) $NMOS => @PLACE(39, -69) => @ORIENT("R0");
//   $SUPPLY @ATTACH &VDD(p) => @SET-SYMBOL $SUPPLY_SYMBOL => @PLACE(39, -50) => @ORIENT("R0") => %vdd4;
//   $GROUND @ATTACH &VSS(p) => @SET-SYMBOL $GROUND_SYMBOL => @PLACE(39, -71) => @ORIENT("R0") => %gnd4;
//   #M55 @SET-SYMBOL(terminals=[[1, "d"], [2, "g"], [3, "s"]]) $PMOS => @PLACE(52, -51) => @ORIENT("R0");
//   #M56 @SET-SYMBOL(terminals=[[1, "d"], [2, "g"], [3, "s"]]) $PMOS => @PLACE(52, -57) => @ORIENT("R0");
//   #M57 @SET-SYMBOL(terminals=[[1, "d"], [2, "g"], [3, "s"]]) $NMOS => @PLACE(52, -63) => @ORIENT("R0");
//   #M58 @SET-SYMBOL(terminals=[[1, "d"], [2, "g"], [3, "s"]]) $NMOS => @PLACE(52, -69) => @ORIENT("R0");
//   $SUPPLY @ATTACH &VDD(p) => @SET-SYMBOL $SUPPLY_SYMBOL => @PLACE(52, -50) => @ORIENT("R0") => %vdd5;
//   $GROUND @ATTACH &VSS(p) => @SET-SYMBOL $GROUND_SYMBOL => @PLACE(52, -71) => @ORIENT("R0") => %gnd5;
//   #M59 @SET-SYMBOL(terminals=[[1, "d"], [2, "g"], [3, "s"]]) $PMOS => @PLACE(64, -51) => @ORIENT("R0");
//   #M60 @SET-SYMBOL(terminals=[[1, "d"], [2, "g"], [3, "s"]]) $PMOS => @PLACE(64, -57) => @ORIENT("R0");
//   #M61 @SET-SYMBOL(terminals=[[1, "d"], [2, "g"], [3, "s"]]) $NMOS => @PLACE(64, -63) => @ORIENT("R0");
//   #M62 @SET-SYMBOL(terminals=[[1, "d"], [2, "g"], [3, "s"]]) $NMOS => @PLACE(64, -69) => @ORIENT("R0");
//   $SUPPLY @ATTACH &VDD(p) => @SET-SYMBOL $SUPPLY_SYMBOL => @PLACE(64, -50) => @ORIENT("R0") => %vdd6;
//   $GROUND @ATTACH &VSS(p) => @SET-SYMBOL $GROUND_SYMBOL => @PLACE(64, -71) => @ORIENT("R0") => %gnd6;
//   #M63 @SET-SYMBOL(terminals=[[1, "d"], [2, "g"], [3, "s"]]) $PMOS => @PLACE(78, -51) => @ORIENT("R0");
//   #M64 @SET-SYMBOL(terminals=[[1, "d"], [2, "g"], [3, "s"]]) $PMOS => @PLACE(78, -57) => @ORIENT("R0");
//   #M65 @SET-SYMBOL(terminals=[[1, "d"], [2, "g"], [3, "s"]]) $NMOS => @PLACE(78, -63) => @ORIENT("R0");
//   #M66 @SET-SYMBOL(terminals=[[1, "d"], [2, "g"], [3, "s"]]) $NMOS => @PLACE(78, -69) => @ORIENT("R0");
//   $SUPPLY @ATTACH &VDD(p) => @SET-SYMBOL $SUPPLY_SYMBOL => @PLACE(78, -50) => @ORIENT("R0") => %vdd7;
//   $GROUND @ATTACH &VSS(p) => @SET-SYMBOL $GROUND_SYMBOL => @PLACE(78, -71) => @ORIENT("R0") => %gnd7;
//   #M67 @SET-SYMBOL(terminals=[[1, "d"], [2, "g"], [3, "s"]]) $PMOS => @PLACE(90, -51) => @ORIENT("R0");
//   #M68 @SET-SYMBOL(terminals=[[1, "d"], [2, "g"], [3, "s"]]) $PMOS => @PLACE(90, -57) => @ORIENT("R0");
//   #M69 @SET-SYMBOL(terminals=[[1, "d"], [2, "g"], [3, "s"]]) $NMOS => @PLACE(90, -63) => @ORIENT("R0");
//   #M70 @SET-SYMBOL(terminals=[[1, "d"], [2, "g"], [3, "s"]]) $NMOS => @PLACE(90, -69) => @ORIENT("R0");
//   $SUPPLY @ATTACH &VDD(p) => @SET-SYMBOL $SUPPLY_SYMBOL => @PLACE(90, -50) => @ORIENT("R0") => %vdd8;
//   $GROUND @ATTACH &VSS(p) => @SET-SYMBOL $GROUND_SYMBOL => @PLACE(90, -71) => @ORIENT("R0") => %gnd8;
//   #M71 @SET-SYMBOL(terminals=[[1, "d"], [2, "g"], [3, "s"]]) $PMOS => @PLACE(138, -35) => @ORIENT("R0");
//   #M72 @SET-SYMBOL(terminals=[[1, "d"], [2, "g"], [3, "s"]]) $PMOS => @PLACE(138, -41) => @ORIENT("R0");
//   #M73 @SET-SYMBOL(terminals=[[1, "d"], [2, "g"], [3, "s"]]) $PMOS => @PLACE(138, -47) => @ORIENT("R0");
//   #M74 @SET-SYMBOL(terminals=[[1, "d"], [2, "g"], [3, "s"]]) $NMOS => @PLACE(138, -53) => @ORIENT("R0");
//   #M75 @SET-SYMBOL(terminals=[[1, "d"], [2, "g"], [3, "s"]]) $NMOS => @PLACE(138, -59) => @ORIENT("R0");
//   #M76 @SET-SYMBOL(terminals=[[1, "d"], [2, "g"], [3, "s"]]) $NMOS => @PLACE(138, -65) => @ORIENT("R0");
//   $SUPPLY @ATTACH &VDD(p) => @SET-SYMBOL $SUPPLY_SYMBOL => @PLACE(138, -33) => @ORIENT("R0") => %vdd9;
//   $IO_PORT @ATTACH &CLK(p) => @SET-SYMBOL $IO_PORT_SYMBOL => @PLACE(135, -47) => @ORIENT("R0") => %port42;
//   $IO_PORT @ATTACH &CLKB(p) => @SET-SYMBOL $IO_PORT_SYMBOL => @PLACE(135, -53) => @ORIENT("R0") => %port43;
//   $GROUND @ATTACH &VSS(p) => @SET-SYMBOL $GROUND_SYMBOL => @PLACE(138, -67) => @ORIENT("R0") => %gnd9;
//   %j1 = (58, -4);
//   %j2 = (48, -4);
//   %j3 = (58, -22);
//   %j4 = (48, -22);
//   %j5 = (101, -4);
//   %j6 = (91, -4);
//   %j7 = (101, -22);
//   %j8 = (91, -22);
//   %j9 = (143, -4);
//   %j10 = (133, -4);
//   %j11 = (143, -22);
//   %j12 = (133, -22);
//   %j13 = (114, -52);
//   %j14 = (110, -52);
//   %j15 = (39, -29);
//   %j16 = (46, -33);
//   %j17 = (46, -29);
//   %j18 = (53, -33);
//   %j19 = (53, -29);
//   %j20 = (60, -33);
//   %j21 = (60, -29);
//   %j22 = (67, -33);
//   %j23 = (67, -29);
//   %j24 = (74, -33);
//   %j25 = (74, -29);
//   %j26 = (81, -33);
//   %j27 = (81, -29);
//   %j28 = (88, -33);
//   %j29 = (88, -29);
//   %j30 = (95, -33);
//   %j31 = (95, -29);
//   %j32 = (102, -33);
//   %j33 = (102, -29);
//   %j34 = (109, -33);
//   %j35 = (109, -29);
//   %j36 = (116, -33);
//   %j37 = (116, -29);
//   %j38 = (53, -41);
//   %j39 = (67, -37);
//   %j40 = (67, -41);
//   %j41 = (81, -37);
//   %j42 = (81, -41);
//   %j43 = (95, -37);
//   %j44 = (95, -41);
//   %j45 = (60, -37);
//   %j46 = (60, -41);
//   %j47 = (74, -37);
//   %j48 = (74, -41);
//   %j49 = (88, -37);
//   %j50 = (88, -41);
//   %j51 = (102, -37);
//   %j52 = (102, -41);
//   %j53 = (107, -63);
//   %j54 = (118, -63);
//   %j55 = (115, -63);
//   %j56 = (110, -71);
//   %j57 = (107, -71);
//   %j58 = (118, -71);
//   %j59 = (115, -71);
//   %j60 = (39, -58);
//   %j61 = (52, -58);
//   %j62 = (64, -58);
//   %j63 = (78, -58);
//   %j64 = (90, -58);
//   %j65 = (39, -60);
//   %j66 = (42, -60);
//   %j67 = (52, -60);
//   %j68 = (55, -60);
//   %j69 = (64, -60);
//   %j70 = (67, -60);
//   %j71 = (78, -60);
//   %j72 = (81, -60);
//   %j73 = (90, -60);
//   %j74 = (93, -60);
//   %j75 = (138, -50);
//   %j76 = (141, -50);
//   &X0 @WIRE(mode="straight") {#M1:1 #M5:3} => %wire1;
//   &net6 @WIRE(mode="straight") {#M5:1 #M9:1};
//   &VDD @WIRE(mode="straight") {#M1:3 (38, -4) %j2};
//   &VDD @WIRE(mode="straight") {%j2 %vdd1::pin};
//   &VDD @WIRE(mode="straight") {%vdd1::pin %j1};
//   &VDD @WIRE(mode="straight") {%j1 (69, -4) #M4:3};
//   &VDD @WIRE(mode="straight") {#M3:3 %j1};
//   &VDD @WIRE(mode="straight") {#M2:3 %j2};
//   &net23 @WIRE(mode="straight") {#M2:1 #M6:3};
//   &X1 @WIRE(mode="straight") {#M6:1 #M10:1} => %wire2;
//   &X2 @WIRE(mode="straight") {#M7:1 #M11:1} => %wire3;
//   &net0 @WIRE(mode="straight") {#M7:3 #M3:1};
//   &X3 @WIRE(mode="straight") {#M4:1 #M8:3} => %wire4;
//   &net3 @WIRE(mode="straight") {#M8:1 #M12:1};
//   &VSS @WIRE(mode="straight") {#M9:3 (38, -22) %j4};
//   &VSS @WIRE(mode="straight") {%j4 %gnd1::pin};
//   &VSS @WIRE(mode="straight") {%gnd1::pin %j3};
//   &VSS @WIRE(mode="straight") {%j3 (69, -22) #M12:3};
//   &VSS @WIRE(mode="straight") {#M11:3 %j3};
//   &VSS @WIRE(mode="straight") {%j4 #M10:3};
//   &X4 @WIRE(mode="straight") {#M13:1 #M17:3} => %wire5;
//   &net7 @WIRE(mode="straight") {#M17:1 #M21:1};
//   &VDD @WIRE(mode="straight") {#M13:3 (81, -4) %j6};
//   &VDD @WIRE(mode="straight") {%j6 %vdd2::pin};
//   &VDD @WIRE(mode="straight") {%vdd2::pin %j5};
//   &VDD @WIRE(mode="straight") {%j5 (112, -4) #M16:3};
//   &VDD @WIRE(mode="straight") {#M15:3 %j5};
//   &VDD @WIRE(mode="straight") {#M14:3 %j6};
//   &net24 @WIRE(mode="straight") {#M14:1 #M18:3};
//   &X5 @WIRE(mode="straight") {#M18:1 #M22:1} => %wire6;
//   &X6 @WIRE(mode="straight") {#M19:1 #M23:1} => %wire7;
//   &net1 @WIRE(mode="straight") {#M19:3 #M15:1};
//   &X7 @WIRE(mode="straight") {#M16:1 #M20:3} => %wire8;
//   &net4 @WIRE(mode="straight") {#M20:1 #M24:1};
//   &VSS @WIRE(mode="straight") {#M21:3 (81, -22) %j8};
//   &VSS @WIRE(mode="straight") {%j8 %gnd2::pin};
//   &VSS @WIRE(mode="straight") {%gnd2::pin %j7};
//   &VSS @WIRE(mode="straight") {%j7 (112, -22) #M24:3};
//   &VSS @WIRE(mode="straight") {#M23:3 %j7};
//   &VSS @WIRE(mode="straight") {%j8 #M22:3};
//   &X8 @WIRE(mode="straight") {#M25:1 #M29:3} => %wire9;
//   &net8 @WIRE(mode="straight") {#M29:1 #M33:1};
//   &VDD @WIRE(mode="straight") {#M25:3 (123, -4) %j10};
//   &VDD @WIRE(mode="straight") {%j10 %vdd3::pin};
//   &VDD @WIRE(mode="straight") {%vdd3::pin %j9};
//   &VDD @WIRE(mode="straight") {%j9 (154, -4) #M28:3};
//   &VDD @WIRE(mode="straight") {#M27:3 %j9};
//   &VDD @WIRE(mode="straight") {#M26:3 %j10};
//   &net25 @WIRE(mode="straight") {#M26:1 #M30:3};
//   &X9 @WIRE(mode="straight") {#M30:1 #M34:1} => %wire10;
//   &X10 @WIRE(mode="straight") {#M31:1 #M35:1} => %wire11;
//   &net2 @WIRE(mode="straight") {#M31:3 #M27:1};
//   &X11 @WIRE(mode="straight") {#M28:1 #M32:3} => %wire12;
//   &net5 @WIRE(mode="straight") {#M32:1 #M36:1};
//   &VSS @WIRE(mode="straight") {#M33:3 (123, -22) %j12};
//   &VSS @WIRE(mode="straight") {%j12 %gnd3::pin};
//   &VSS @WIRE(mode="straight") {%gnd3::pin %j11};
//   &VSS @WIRE(mode="straight") {%j11 (154, -22) #M36:3};
//   &VSS @WIRE(mode="straight") {#M35:3 %j11};
//   &VSS @WIRE(mode="straight") {%j12 #M34:3};
//   &D @WIRE(mode="straight") {#M37:3 %j14};
//   &D @WIRE(mode="straight") {%j14 #M38:3};
//   &Q @WIRE(mode="straight") {#M37:1 %j13};
//   &Q @WIRE(mode="straight") {%j13 #M38:1};
//   &Q @WIRE(mode="straight") {%port40::pin %j13};
//   &D @WIRE(mode="straight") {%j14 %port39::pin};
//   &CLK @WIRE(mode="straight") {#M39:2 #M40:2};
//   &CLK @WIRE(mode="straight") {#M40:2 #M41:2};
//   &CLK @WIRE(mode="straight") {#M41:2 #M42:2};
//   &CLK @WIRE(mode="straight") {#M42:2 #M43:2};
//   &CLK @WIRE(mode="straight") {#M43:2 #M44:2};
//   &CLK @WIRE(mode="straight") {#M44:2 #M45:2};
//   &CLK @WIRE(mode="straight") {#M45:2 #M46:2};
//   &CLK @WIRE(mode="straight") {#M46:2 #M47:2};
//   &CLK @WIRE(mode="straight") {#M47:2 #M48:2};
//   &CLK @WIRE(mode="straight") {#M48:2 #M49:2};
//   &CLK @WIRE(mode="straight") {#M49:2 #M50:2};
//   &X0 @WIRE(mode="straight") {#M39:1 %j15} => %wire13;
//   &X1 @WIRE(mode="straight") {%j16 %j17} => %wire14;
//   &X2 @WIRE(mode="straight") {%j18 %j19} => %wire15;
//   &X3 @WIRE(mode="straight") {%j20 %j21} => %wire16;
//   &X4 @WIRE(mode="straight") {%j22 %j23} => %wire17;
//   &X5 @WIRE(mode="straight") {%j24 %j25} => %wire18;
//   &X6 @WIRE(mode="straight") {%j26 %j27} => %wire19;
//   &X7 @WIRE(mode="straight") {%j28 %j29} => %wire20;
//   &X8 @WIRE(mode="straight") {%j30 %j31} => %wire21;
//   &X9 @WIRE(mode="straight") {%j32 %j33} => %wire22;
//   &X10 @WIRE(mode="straight") {%j34 %j35} => %wire23;
//   &X11 @WIRE(mode="straight") {%j36 %j37} => %wire24;
//   &D @WIRE(mode="straight") {#M39:3 (39, -41) %j38} => %wire25;
//   &D @WIRE(mode="straight") {%j38 %j46};
//   &D @WIRE(mode="straight") {%j46 %j40};
//   &D @WIRE(mode="straight") {%j40 %j48};
//   &D @WIRE(mode="straight") {%j48 %j42};
//   &D @WIRE(mode="straight") {%j42 %j50};
//   &D @WIRE(mode="straight") {%j50 %j44};
//   &D @WIRE(mode="straight") {%j44 %j52};
//   &D @WIRE(mode="straight") {%j52 (109, -41) #M49:3};
//   &DN @WIRE(mode="straight") {#M40:3 (46, -44) (116, -44) #M50:3} => %wire26;
//   &D @WIRE(mode="straight") {#M41:3 %j38};
//   &D @WIRE(mode="straight") {%j39 %j40};
//   &D @WIRE(mode="straight") {%j41 %j42};
//   &D @WIRE(mode="straight") {%j43 %j44};
//   &D @WIRE(mode="straight") {%j45 %j46};
//   &D @WIRE(mode="straight") {%j47 %j48};
//   &D @WIRE(mode="straight") {%j49 %j50};
//   &D @WIRE(mode="straight") {%j51 %j52};
//   &D @WIRE(mode="straight") {#X1:1 %j53} => %wire27;
//   &DN @WIRE(mode="straight") {%j54 %j55} => %wire28;
//   &CLK @WIRE(mode="straight") {%j56 %j57};
//   &CLKB @WIRE(mode="straight") {%j58 %j59} => %wire29;
//   &net9 @WIRE(mode="straight") {#M51:1 #M52:3};
//   &X12 @WIRE(mode="straight") {%j60 #M52:1};
//   &X12 @WIRE(mode="straight") {#M52:1 %j65};
//   &X12 @WIRE(mode="straight") {%j65 #M53:1};
//   &net14 @WIRE(mode="straight") {#M53:3 #M54:1};
//   &VDD @WIRE(mode="straight") {#M51:3 %vdd4::pin};
//   &X3 @WIRE(mode="straight") {#M51:2 (33, -51) (33, -69) #M54:2} => %wire30;
//   &X5 @WIRE(mode="straight") {#M52:2 #M53:2};
//   &net10 @WIRE(mode="straight") {#M55:1 #M56:3};
//   &X13 @WIRE(mode="straight") {%j61 #M56:1};
//   &X13 @WIRE(mode="straight") {#M56:1 %j67};
//   &X13 @WIRE(mode="straight") {%j67 #M57:1};
//   &net15 @WIRE(mode="straight") {#M57:3 #M58:1};
//   &VDD @WIRE(mode="straight") {#M55:3 %vdd5::pin};
//   &X7 @WIRE(mode="straight") {#M55:2 (46, -51) (46, -69) #M58:2} => %wire31;
//   &X9 @WIRE(mode="straight") {#M56:2 #M57:2};
//   &net11 @WIRE(mode="straight") {#M59:1 #M60:3};
//   &X14 @WIRE(mode="straight") {%j62 #M60:1};
//   &X14 @WIRE(mode="straight") {#M60:1 %j69};
//   &X14 @WIRE(mode="straight") {%j69 #M61:1};
//   &net16 @WIRE(mode="straight") {#M61:3 #M62:1};
//   &VDD @WIRE(mode="straight") {#M59:3 %vdd6::pin};
//   &X11 @WIRE(mode="straight") {#M59:2 (58, -51) (58, -69) #M62:2} => %wire32;
//   &X1 @WIRE(mode="straight") {#M60:2 #M61:2};
//   &net12 @WIRE(mode="straight") {#M63:1 #M64:3};
//   &X15 @WIRE(mode="straight") {%j63 #M64:1};
//   &X15 @WIRE(mode="straight") {#M64:1 %j71};
//   &X15 @WIRE(mode="straight") {%j71 #M65:1};
//   &net17 @WIRE(mode="straight") {#M65:3 #M66:1};
//   &VDD @WIRE(mode="straight") {#M63:3 %vdd7::pin};
//   &X12 @WIRE(mode="straight") {#M63:2 (72, -51) (72, -69) #M66:2} => %wire33;
//   &X13 @WIRE(mode="straight") {#M64:2 #M65:2};
//   &net13 @WIRE(mode="straight") {#M67:1 #M68:3};
//   &X16 @WIRE(mode="straight") {%j64 #M68:1};
//   &X16 @WIRE(mode="straight") {#M68:1 %j73};
//   &X16 @WIRE(mode="straight") {%j73 #M69:1};
//   &net18 @WIRE(mode="straight") {#M69:3 #M70:1};
//   &VDD @WIRE(mode="straight") {#M67:3 %vdd8::pin};
//   &X13 @WIRE(mode="straight") {#M67:2 (84, -51) (84, -69) #M70:2} => %wire34;
//   &X14 @WIRE(mode="straight") {#M68:2 #M69:2};
//   &net19 @WIRE(mode="straight") {#M71:1 #M72:3};
//   &net20 @WIRE(mode="straight") {#M72:1 #M73:3};
//   &Q @WIRE(mode="straight") {#M73:1 %j75};
//   &Q @WIRE(mode="straight") {%j75 #M74:1};
//   &net21 @WIRE(mode="straight") {#M74:3 #M75:1};
//   &net22 @WIRE(mode="straight") {#M75:3 #M76:1};
//   &X15 @WIRE(mode="straight") {#M71:2 (129, -35) (129, -65) #M76:2};
//   &X16 @WIRE(mode="straight") {#M72:2 (131, -41) (131, -59) #M75:2} => %wire35;
//   &X12 @WIRE(mode="straight") {%j65 %j66};
//   &X13 @WIRE(mode="straight") {%j67 %j68} => %wire36;
//   &X14 @WIRE(mode="straight") {%j69 %j70} => %wire37;
//   &X15 @WIRE(mode="straight") {%j71 %j72} => %wire38;
//   &X16 @WIRE(mode="straight") {%j73 %j74};
//   &Q @WIRE(mode="straight") {%j75 %j76};
//   $JUNCTION @ATTACH %j14(p) => @PLACE(110, -52) => %dot1;
//   $JUNCTION @ATTACH %j13(p) => @PLACE(114, -52) => %dot2;
//   &VSS @WIRE(mode="straight") {%gnd4::pin #M54:3};
//   &VSS @WIRE(mode="straight") {%gnd5::pin #M58:3};
//   &VSS @WIRE(mode="straight") {%gnd6::pin #M62:3};
//   &VSS @WIRE(mode="straight") {%gnd7::pin #M66:3};
//   &VSS @WIRE(mode="straight") {%gnd8::pin #M70:3};
//   &VSS @WIRE(mode="straight") {%gnd9::pin #M76:3};
//   &X3 @WIRE(mode="straight") {#M1:2 %port1::pin};
//   &X0 @WIRE(mode="straight") {#M4:2 %port10::pin};
//   &X1 @WIRE(mode="straight") {#M8:2 %port11::pin};
//   &X2 @WIRE(mode="straight") {#M12:2 %port12::pin};
//   &X7 @WIRE(mode="straight") {#M13:2 %port13::pin};
//   &X4 @WIRE(mode="straight") {#M16:2 %port19::pin};
//   &X5 @WIRE(mode="straight") {#M20:2 %port20::pin};
//   &X6 @WIRE(mode="straight") {#M24:2 %port21::pin};
//   &X6 @WIRE(mode="straight") {#M17:2 %port14::pin};
//   &X5 @WIRE(mode="straight") {#M21:2 %port15::pin};
//   &X6 @WIRE(mode="straight") {#M22:2 %port16::pin};
//   &X2 @WIRE(mode="straight") {#M5:2 %port2::pin};
//   &X6 @WIRE(mode="straight") {#M18:2 %port17::pin};
//   &X4 @WIRE(mode="straight") {#M14:2 %port18::pin};
//   &X5 @WIRE(mode="straight") {#M23:2 %port29::pin};
//   &X11 @WIRE(mode="straight") {#M27:2 %port31::pin};
//   &X5 @WIRE(mode="straight") {#M19:2 %port30::pin};
//   &X11 @WIRE(mode="straight") {#M25:2 %port22::pin};
//   &X9 @WIRE(mode="straight") {#M32:2 %port35::pin};
//   &X10 @WIRE(mode="straight") {#M36:2 %port36::pin};
//   &X10 @WIRE(mode="straight") {#M29:2 %port23::pin};
//   &X1 @WIRE(mode="straight") {#M9:2 %port3::pin};
//   &X9 @WIRE(mode="straight") {#M33:2 %port24::pin};
//   &X10 @WIRE(mode="straight") {#M34:2 %port25::pin};
//   &X10 @WIRE(mode="straight") {#M30:2 %port26::pin};
//   &X8 @WIRE(mode="straight") {#M26:2 %port27::pin};
//   &X9 @WIRE(mode="straight") {#M31:2 %port32::pin};
//   &X9 @WIRE(mode="straight") {#M35:2 %port33::pin};
//   &X8 @WIRE(mode="straight") {#M28:2 %port34::pin};
//   &X7 @WIRE(mode="straight") {#M15:2 %port28::pin};
//   &X2 @WIRE(mode="straight") {#M10:2 %port4::pin};
//   &X2 @WIRE(mode="straight") {#M6:2 %port5::pin};
//   &X0 @WIRE(mode="straight") {#M2:2 %port6::pin};
//   &X3 @WIRE(mode="straight") {#M3:2 %port7::pin};
//   &X1 @WIRE(mode="straight") {#M7:2 %port8::pin};
//   &X1 @WIRE(mode="straight") {#M11:2 %port9::pin};
//   &CLK @WIRE(mode="straight") {#M37:2 %port37::pin};
//   &CLK @WIRE(mode="straight") {#M39:2 %port41::pin};
//   &CLKB @WIRE(mode="straight") {#M38:2 %port38::pin};
//   &CLK @WIRE(mode="straight") {#M73:2 %port42::pin};
//   &CLKB @WIRE(mode="straight") {#M74:2 %port43::pin};
//   &VDD @WIRE(mode="straight") {#M71:3 %vdd9::pin};
//   $JUNCTION @ATTACH %j4(p) => @PLACE(48, -22) => %dot3;
//   $JUNCTION @ATTACH (53, -22)(p) => @PLACE(53, -22) => %dot4;
//   $JUNCTION @ATTACH %j3(p) => @PLACE(58, -22) => %dot5;
//   $JUNCTION @ATTACH %j8(p) => @PLACE(91, -22) => %dot6;
//   $JUNCTION @ATTACH (96, -22)(p) => @PLACE(96, -22) => %dot7;
//   $JUNCTION @ATTACH %j7(p) => @PLACE(101, -22) => %dot8;
//   $JUNCTION @ATTACH %j12(p) => @PLACE(133, -22) => %dot9;
//   $JUNCTION @ATTACH (138, -22)(p) => @PLACE(138, -22) => %dot10;
//   $JUNCTION @ATTACH %j11(p) => @PLACE(143, -22) => %dot11;
//   &X9 @WIRE(mode="straight") {%j32 #M48:1};
//   &X10 @WIRE(mode="straight") {%j34 #M49:1};
//   &X11 @WIRE(mode="straight") {%j36 #M50:1};
//   &X2 @WIRE(mode="straight") {%j18 #M41:1};
//   &X3 @WIRE(mode="straight") {%j20 #M42:1};
//   &X1 @WIRE(mode="straight") {%j16 #M40:1};
//   &X4 @WIRE(mode="straight") {%j22 #M43:1};
//   &X5 @WIRE(mode="straight") {%j24 #M44:1};
//   &X6 @WIRE(mode="straight") {%j26 #M45:1};
//   &X7 @WIRE(mode="straight") {%j28 #M46:1};
//   &X8 @WIRE(mode="straight") {%j30 #M47:1};
//   $JUNCTION @ATTACH %j38(p) => @PLACE(53, -41) => %dot12;
//   &D @WIRE(mode="straight") {%j45 #M42:3};
//   $JUNCTION @ATTACH %j46(p) => @PLACE(60, -41) => %dot13;
//   &D @WIRE(mode="straight") {%j39 #M43:3};
//   $JUNCTION @ATTACH %j40(p) => @PLACE(67, -41) => %dot14;
//   &D @WIRE(mode="straight") {%j47 #M44:3};
//   $JUNCTION @ATTACH %j48(p) => @PLACE(74, -41) => %dot15;
//   &D @WIRE(mode="straight") {%j41 #M45:3};
//   $JUNCTION @ATTACH %j42(p) => @PLACE(81, -41) => %dot16;
//   &D @WIRE(mode="straight") {%j49 #M46:3};
//   $JUNCTION @ATTACH %j50(p) => @PLACE(88, -41) => %dot17;
//   &D @WIRE(mode="straight") {%j43 #M47:3};
//   $JUNCTION @ATTACH %j44(p) => @PLACE(95, -41) => %dot18;
//   &D @WIRE(mode="straight") {%j51 #M48:3};
//   $JUNCTION @ATTACH %j52(p) => @PLACE(102, -41) => %dot19;
//   $JUNCTION @ATTACH %j2(p) => @PLACE(48, -4) => %dot20;
//   $JUNCTION @ATTACH (53, -4)(p) => @PLACE(53, -4) => %dot21;
//   $JUNCTION @ATTACH %j1(p) => @PLACE(58, -4) => %dot22;
//   $JUNCTION @ATTACH %j6(p) => @PLACE(91, -4) => %dot23;
//   $JUNCTION @ATTACH (96, -4)(p) => @PLACE(96, -4) => %dot24;
//   $JUNCTION @ATTACH %j5(p) => @PLACE(101, -4) => %dot25;
//   $JUNCTION @ATTACH %j10(p) => @PLACE(133, -4) => %dot26;
//   $JUNCTION @ATTACH (138, -4)(p) => @PLACE(138, -4) => %dot27;
//   $JUNCTION @ATTACH %j9(p) => @PLACE(143, -4) => %dot28;
//   &DN @WIRE(mode="straight") {%j55 #X1:2};
//   &CLK @WIRE(mode="straight") {%j56 #X2:1};
//   &CLKB @WIRE(mode="straight") {%j59 #X2:2};
//   $JUNCTION @ATTACH %j65(p) => @PLACE(39, -60) => %dot29;
//   $JUNCTION @ATTACH %j75(p) => @PLACE(138, -50) => %dot30;
//   $JUNCTION @ATTACH %j67(p) => @PLACE(52, -60) => %dot31;
//   $JUNCTION @ATTACH %j69(p) => @PLACE(64, -60) => %dot32;
//   $JUNCTION @ATTACH %j71(p) => @PLACE(78, -60) => %dot33;
//   $JUNCTION @ATTACH %j73(p) => @PLACE(90, -60) => %dot34;
//   #M1
//       @TEXT("\textbf{\textit{M}}_{\textbf{1}}", key="name", dx=0.4, dy=-0.5, halign="start", valign="baseline", size=1.5116,
//       bold=false, textvisible=true);
//   $CANVAS_LABEL @ATTACH(bind="name") #M1::name(label);
//   #M2
//       @TEXT("\textbf{\textit{M}}_{\textbf{2}}", key="name", dx=0.4, dy=-0.5, halign="start", valign="baseline", size=1.5116,
//       bold=false, textvisible=true);
//   $CANVAS_LABEL @ATTACH(bind="name") #M2::name(label);
//   #M3
//       @TEXT("\textbf{\textit{M}}_{\textbf{3}}", key="name", dx=0.4, dy=-0.5, halign="start", valign="baseline", size=1.5116,
//       bold=false, textvisible=true);
//   $CANVAS_LABEL @ATTACH(bind="name") #M3::name(label);
//   #M4
//       @TEXT("\textbf{\textit{M}}_{\textbf{4}}", key="name", dx=0.4, dy=-0.5, halign="start", valign="baseline", size=1.5116,
//       bold=false, textvisible=true);
//   $CANVAS_LABEL @ATTACH(bind="name") #M4::name(label);
//   #M5
//       @TEXT("\textbf{\textit{M}}_{\textbf{5}}", key="name", dx=0.4, dy=-0.5, halign="start", valign="baseline", size=1.5116,
//       bold=false, textvisible=true);
//   $CANVAS_LABEL @ATTACH(bind="name") #M5::name(label);
//   #M6
//       @TEXT("\textbf{\textit{M}}_{\textbf{6}}", key="name", dx=0.4, dy=-0.5, halign="start", valign="baseline", size=1.5116,
//       bold=false, textvisible=true);
//   $CANVAS_LABEL @ATTACH(bind="name") #M6::name(label);
//   #M7
//       @TEXT("\textbf{\textit{M}}_{\textbf{7}}", key="name", dx=0.4, dy=-0.5, halign="start", valign="baseline", size=1.5116,
//       bold=false, textvisible=true);
//   $CANVAS_LABEL @ATTACH(bind="name") #M7::name(label);
//   #M8
//       @TEXT("\textbf{\textit{M}}_{\textbf{8}}", key="name", dx=0.4, dy=-0.5, halign="start", valign="baseline", size=1.5116,
//       bold=false, textvisible=true);
//   $CANVAS_LABEL @ATTACH(bind="name") #M8::name(label);
//   #M9
//       @TEXT("\textbf{\textit{M}}_{\textbf{9}}", key="name", dx=0.5, dy=-0.5, halign="start", valign="baseline", size=1.5116,
//       bold=false, textvisible=true);
//   $CANVAS_LABEL @ATTACH(bind="name") #M9::name(label);
//   #M10
//       @TEXT("\textbf{\textit{M}}_{\textbf{10}}", key="name", dx=0.5, dy=-0.5, halign="start", valign="baseline", size=1.5116,
//       bold=false, textvisible=true);
//   $CANVAS_LABEL @ATTACH(bind="name") #M10::name(label);
//   #M11
//       @TEXT("\textbf{\textit{M}}_{\textbf{11}}", key="name", dx=0.5, dy=-0.5, halign="start", valign="baseline", size=1.5116,
//       bold=false, textvisible=true);
//   $CANVAS_LABEL @ATTACH(bind="name") #M11::name(label);
//   #M12
//       @TEXT("\textbf{\textit{M}}_{\textbf{12}}", key="name", dx=0.5, dy=-0.5, halign="start", valign="baseline", size=1.5116,
//       bold=false, textvisible=true);
//   $CANVAS_LABEL @ATTACH(bind="name") #M12::name(label);
//   %port1
//       @TEXT("\textbf{\textit{X}}_{\textbf{3}}", key="netname", dx=-2, dy=-0.5, halign="end", valign="baseline", size=1.5116,
//       bold=false, textvisible=true);
//   $CANVAS_LABEL @ATTACH(bind="port") %port1::netname(label);
//   %port2
//       @TEXT("\textbf{\textit{X}}_{\textbf{2}}", key="netname", dx=-2, dy=-0.5, halign="end", valign="baseline", size=1.5116,
//       bold=false, textvisible=true);
//   $CANVAS_LABEL @ATTACH(bind="port") %port2::netname(label);
//   %port3
//       @TEXT("\textbf{\textit{X}}_{\textbf{1}}", key="netname", dx=-2, dy=-0.5, halign="end", valign="baseline", size=1.5116,
//       bold=false, textvisible=true);
//   $CANVAS_LABEL @ATTACH(bind="port") %port3::netname(label);
//   %port4
//       @TEXT("\textbf{\textit{X}}_{\textbf{2}}", key="netname", dx=-1.5, dy=-0.5, halign="end", valign="baseline", size=1.5116,
//       bold=false, textvisible=true);
//   $CANVAS_LABEL @ATTACH(bind="port") %port4::netname(label);
//   %port5
//       @TEXT("\textbf{\textit{X}}_{\textbf{2}}", key="netname", dx=-1.5, dy=-0.5, halign="end", valign="baseline", size=1.5116,
//       bold=false, textvisible=true);
//   $CANVAS_LABEL @ATTACH(bind="port") %port5::netname(label);
//   %port6
//       @TEXT("\textbf{\textit{X}}_{\textbf{0}}", key="netname", dx=-1.5, dy=-0.5, halign="end", valign="baseline", size=1.5116,
//       bold=false, textvisible=true);
//   $CANVAS_LABEL @ATTACH(bind="port") %port6::netname(label);
//   %port7
//       @TEXT("\textbf{\textit{X}}_{\textbf{3}}", key="netname", dx=-1.5, dy=-0.5, halign="end", valign="baseline", size=1.5116,
//       bold=false, textvisible=true);
//   $CANVAS_LABEL @ATTACH(bind="port") %port7::netname(label);
//   %port8
//       @TEXT("\textbf{\textit{X}}_{\textbf{1}}", key="netname", dx=-1.5, dy=-0.5, halign="end", valign="baseline", size=1.5116,
//       bold=false, textvisible=true);
//   $CANVAS_LABEL @ATTACH(bind="port") %port8::netname(label);
//   %port9
//       @TEXT("\textbf{\textit{X}}_{\textbf{1}}", key="netname", dx=-1.5, dy=-0.5, halign="end", valign="baseline", size=1.5116,
//       bold=false, textvisible=true);
//   $CANVAS_LABEL @ATTACH(bind="port") %port9::netname(label);
//   %port10
//       @TEXT("\textbf{\textit{X}}_{\textbf{0}}", key="netname", dx=-1.5, dy=-0.5, halign="end", valign="baseline", size=1.5116,
//       bold=false, textvisible=true);
//   $CANVAS_LABEL @ATTACH(bind="port") %port10::netname(label);
//   %port11
//       @TEXT("\textbf{\textit{X}}_{\textbf{1}}", key="netname", dx=-1.5, dy=-0.5, halign="end", valign="baseline", size=1.5116,
//       bold=false, textvisible=true);
//   $CANVAS_LABEL @ATTACH(bind="port") %port11::netname(label);
//   %port12
//       @TEXT("\textbf{\textit{X}}_{\textbf{2}}", key="netname", dx=-1.5, dy=-0.5, halign="end", valign="baseline", size=1.5116,
//       bold=false, textvisible=true);
//   $CANVAS_LABEL @ATTACH(bind="port") %port12::netname(label);
//   %vdd1 @TEXT("\textbf{\textit{V}}_{\textbf{DD}}", dx=2, dy=1, size=1.5116, bold=false) => %power1;
//   $CANVAS_LABEL @ATTACH(bind="port") %power1(label);
//   #M13
//       @TEXT("\textbf{\textit{M}}_{\textbf{13}}", key="name", dx=0.4, dy=-0.5, halign="start", valign="baseline", size=1.5116,
//       bold=false, textvisible=true);
//   $CANVAS_LABEL @ATTACH(bind="name") #M13::name(label);
//   #M14
//       @TEXT("\textbf{\textit{M}}_{\textbf{14}}", key="name", dx=0.4, dy=-0.5, halign="start", valign="baseline", size=1.5116,
//       bold=false, textvisible=true);
//   $CANVAS_LABEL @ATTACH(bind="name") #M14::name(label);
//   #M15
//       @TEXT("\textbf{\textit{M}}_{\textbf{15}}", key="name", dx=0.4, dy=-0.5, halign="start", valign="baseline", size=1.5116,
//       bold=false, textvisible=true);
//   $CANVAS_LABEL @ATTACH(bind="name") #M15::name(label);
//   #M16
//       @TEXT("\textbf{\textit{M}}_{\textbf{16}}", key="name", dx=0.4, dy=-0.5, halign="start", valign="baseline", size=1.5116,
//       bold=false, textvisible=true);
//   $CANVAS_LABEL @ATTACH(bind="name") #M16::name(label);
//   #M17
//       @TEXT("\textbf{\textit{M}}_{\textbf{17}}", key="name", dx=0.4, dy=-0.5, halign="start", valign="baseline", size=1.5116,
//       bold=false, textvisible=true);
//   $CANVAS_LABEL @ATTACH(bind="name") #M17::name(label);
//   #M18
//       @TEXT("\textbf{\textit{M}}_{\textbf{18}}", key="name", dx=0.4, dy=-0.5, halign="start", valign="baseline", size=1.5116,
//       bold=false, textvisible=true);
//   $CANVAS_LABEL @ATTACH(bind="name") #M18::name(label);
//   #M19
//       @TEXT("\textbf{\textit{M}}_{\textbf{19}}", key="name", dx=0.4, dy=-0.5, halign="start", valign="baseline", size=1.5116,
//       bold=false, textvisible=true);
//   $CANVAS_LABEL @ATTACH(bind="name") #M19::name(label);
//   #M20
//       @TEXT("\textbf{\textit{M}}_{\textbf{20}}", key="name", dx=0.4, dy=-0.5, halign="start", valign="baseline", size=1.5116,
//       bold=false, textvisible=true);
//   $CANVAS_LABEL @ATTACH(bind="name") #M20::name(label);
//   #M21
//       @TEXT("\textbf{\textit{M}}_{\textbf{21}}", key="name", dx=0.5, dy=-0.5, halign="start", valign="baseline", size=1.5116,
//       bold=false, textvisible=true);
//   $CANVAS_LABEL @ATTACH(bind="name") #M21::name(label);
//   #M22
//       @TEXT("\textbf{\textit{M}}_{\textbf{22}}", key="name", dx=0.5, dy=-0.5, halign="start", valign="baseline", size=1.5116,
//       bold=false, textvisible=true);
//   $CANVAS_LABEL @ATTACH(bind="name") #M22::name(label);
//   #M23
//       @TEXT("\textbf{\textit{M}}_{\textbf{23}}", key="name", dx=0.5, dy=-0.5, halign="start", valign="baseline", size=1.5116,
//       bold=false, textvisible=true);
//   $CANVAS_LABEL @ATTACH(bind="name") #M23::name(label);
//   #M24
//       @TEXT("\textbf{\textit{M}}_{\textbf{24}}", key="name", dx=0.5, dy=-0.5, halign="start", valign="baseline", size=1.5116,
//       bold=false, textvisible=true);
//   $CANVAS_LABEL @ATTACH(bind="name") #M24::name(label);
//   %port13
//       @TEXT("\textbf{\textit{X}}_{\textbf{7}}", key="netname", dx=-2, dy=-0.5, halign="end", valign="baseline", size=1.5116,
//       bold=false, textvisible=true);
//   $CANVAS_LABEL @ATTACH(bind="port") %port13::netname(label);
//   %port14
//       @TEXT("\textbf{\textit{X}}_{\textbf{6}}", key="netname", dx=-2, dy=-0.5, halign="end", valign="baseline", size=1.5116,
//       bold=false, textvisible=true);
//   $CANVAS_LABEL @ATTACH(bind="port") %port14::netname(label);
//   %port15
//       @TEXT("\textbf{\textit{X}}_{\textbf{5}}", key="netname", dx=-2, dy=-0.5, halign="end", valign="baseline", size=1.5116,
//       bold=false, textvisible=true);
//   $CANVAS_LABEL @ATTACH(bind="port") %port15::netname(label);
//   %port16
//       @TEXT("\textbf{\textit{X}}_{\textbf{6}}", key="netname", dx=-1.5, dy=-0.5, halign="end", valign="baseline", size=1.5116,
//       bold=false, textvisible=true);
//   $CANVAS_LABEL @ATTACH(bind="port") %port16::netname(label);
//   %port17
//       @TEXT("\textbf{\textit{X}}_{\textbf{6}}", key="netname", dx=-1.5, dy=-0.5, halign="end", valign="baseline", size=1.5116,
//       bold=false, textvisible=true);
//   $CANVAS_LABEL @ATTACH(bind="port") %port17::netname(label);
//   %port18
//       @TEXT("\textbf{\textit{X}}_{\textbf{4}}", key="netname", dx=-1.5, dy=-0.5, halign="end", valign="baseline", size=1.5116,
//       bold=false, textvisible=true);
//   $CANVAS_LABEL @ATTACH(bind="port") %port18::netname(label);
//   %port19
//       @TEXT("\textbf{\textit{X}}_{\textbf{4}}", key="netname", dx=-1.5, dy=-0.5, halign="end", valign="baseline", size=1.5116,
//       bold=false, textvisible=true);
//   $CANVAS_LABEL @ATTACH(bind="port") %port19::netname(label);
//   %port20
//       @TEXT("\textbf{\textit{X}}_{\textbf{5}}", key="netname", dx=-1.5, dy=-0.5, halign="end", valign="baseline", size=1.5116,
//       bold=false, textvisible=true);
//   $CANVAS_LABEL @ATTACH(bind="port") %port20::netname(label);
//   %port21
//       @TEXT("\textbf{\textit{X}}_{\textbf{6}}", key="netname", dx=-1.5, dy=-0.5, halign="end", valign="baseline", size=1.5116,
//       bold=false, textvisible=true);
//   $CANVAS_LABEL @ATTACH(bind="port") %port21::netname(label);
//   %vdd2 @TEXT("\textbf{\textit{V}}_{\textbf{DD}}", dx=2, dy=1, size=1.5116, bold=false) => %power2;
//   $CANVAS_LABEL @ATTACH(bind="port") %power2(label);
//   #M25
//       @TEXT("\textbf{\textit{M}}_{\textbf{25}}", key="name", dx=0.4, dy=-0.5, halign="start", valign="baseline", size=1.5116,
//       bold=false, textvisible=true);
//   $CANVAS_LABEL @ATTACH(bind="name") #M25::name(label);
//   #M26
//       @TEXT("\textbf{\textit{M}}_{\textbf{26}}", key="name", dx=0.4, dy=-0.5, halign="start", valign="baseline", size=1.5116,
//       bold=false, textvisible=true);
//   $CANVAS_LABEL @ATTACH(bind="name") #M26::name(label);
//   #M27
//       @TEXT("\textbf{\textit{M}}_{\textbf{27}}", key="name", dx=0.4, dy=-0.5, halign="start", valign="baseline", size=1.5116,
//       bold=false, textvisible=true);
//   $CANVAS_LABEL @ATTACH(bind="name") #M27::name(label);
//   #M28
//       @TEXT("\textbf{\textit{M}}_{\textbf{28}}", key="name", dx=0.4, dy=-0.5, halign="start", valign="baseline", size=1.5116,
//       bold=false, textvisible=true);
//   $CANVAS_LABEL @ATTACH(bind="name") #M28::name(label);
//   #M29
//       @TEXT("\textbf{\textit{M}}_{\textbf{29}}", key="name", dx=0.4, dy=-0.5, halign="start", valign="baseline", size=1.5116,
//       bold=false, textvisible=true);
//   $CANVAS_LABEL @ATTACH(bind="name") #M29::name(label);
//   #M30
//       @TEXT("\textbf{\textit{M}}_{\textbf{30}}", key="name", dx=0.4, dy=-0.5, halign="start", valign="baseline", size=1.5116,
//       bold=false, textvisible=true);
//   $CANVAS_LABEL @ATTACH(bind="name") #M30::name(label);
//   #M31
//       @TEXT("\textbf{\textit{M}}_{\textbf{31}}", key="name", dx=0.4, dy=-0.5, halign="start", valign="baseline", size=1.5116,
//       bold=false, textvisible=true);
//   $CANVAS_LABEL @ATTACH(bind="name") #M31::name(label);
//   #M32
//       @TEXT("\textbf{\textit{M}}_{\textbf{32}}", key="name", dx=0.4, dy=-0.5, halign="start", valign="baseline", size=1.5116,
//       bold=false, textvisible=true);
//   $CANVAS_LABEL @ATTACH(bind="name") #M32::name(label);
//   #M33
//       @TEXT("\textbf{\textit{M}}_{\textbf{33}}", key="name", dx=0.5, dy=-0.5, halign="start", valign="baseline", size=1.5116,
//       bold=false, textvisible=true);
//   $CANVAS_LABEL @ATTACH(bind="name") #M33::name(label);
//   #M34
//       @TEXT("\textbf{\textit{M}}_{\textbf{34}}", key="name", dx=0.5, dy=-0.5, halign="start", valign="baseline", size=1.5116,
//       bold=false, textvisible=true);
//   $CANVAS_LABEL @ATTACH(bind="name") #M34::name(label);
//   #M35
//       @TEXT("\textbf{\textit{M}}_{\textbf{35}}", key="name", dx=0.5, dy=-0.5, halign="start", valign="baseline", size=1.5116,
//       bold=false, textvisible=true);
//   $CANVAS_LABEL @ATTACH(bind="name") #M35::name(label);
//   #M36
//       @TEXT("\textbf{\textit{M}}_{\textbf{36}}", key="name", dx=0.5, dy=-0.5, halign="start", valign="baseline", size=1.5116,
//       bold=false, textvisible=true);
//   $CANVAS_LABEL @ATTACH(bind="name") #M36::name(label);
//   %port22
//       @TEXT("\textbf{\textit{X}}_{\textbf{11}}", key="netname", dx=-1, dy=-0.5, halign="end", valign="baseline", size=1.5116,
//       bold=false, textvisible=true);
//   $CANVAS_LABEL @ATTACH(bind="port") %port22::netname(label);
//   %port23
//       @TEXT("\textbf{\textit{X}}_{\textbf{10}}", key="netname", dx=-1.5, dy=0, halign="end", valign="baseline", size=1.5116,
//       bold=false, textvisible=true);
//   $CANVAS_LABEL @ATTACH(bind="port") %port23::netname(label);
//   %port24
//       @TEXT("\textbf{\textit{X}}_{\textbf{9}}", key="netname", dx=-1.5, dy=-0.5, halign="end", valign="baseline", size=1.5116,
//       bold=false, textvisible=true);
//   $CANVAS_LABEL @ATTACH(bind="port") %port24::netname(label);
//   %port25
//       @TEXT("\textbf{\textit{X}}_{\textbf{10}}", key="netname", dx=-1, dy=-0.5, halign="end", valign="baseline", size=1.5116,
//       bold=false, textvisible=true);
//   $CANVAS_LABEL @ATTACH(bind="port") %port25::netname(label);
//   %port26
//       @TEXT("\textbf{\textit{X}}_{\textbf{10}}", key="netname", dx=-1, dy=-1.5, halign="end", valign="baseline", size=1.5116,
//       bold=false, textvisible=true);
//   $CANVAS_LABEL @ATTACH(bind="port") %port26::netname(label);
//   %port27
//       @TEXT("\textbf{\textit{X}}_{\textbf{8}}", key="netname", dx=-1, dy=-1.5, halign="end", valign="baseline", size=1.5116,
//       bold=false, textvisible=true);
//   $CANVAS_LABEL @ATTACH(bind="port") %port27::netname(label);
//   %vdd3 @TEXT("\textbf{\textit{V}}_{\textbf{DD}}", dx=2, dy=1, size=1.5116, bold=false) => %power3;
//   $CANVAS_LABEL @ATTACH(bind="port") %power3(label);
//   %wire1 @TEXT("\textbf{\textit{X}}_{\textbf{0}}", size=1.5116, bold=false, textcolor="#dc2626") => @PLACE(38.8, -10) => %label1;
//   $CANVAS_LABEL @ATTACH(bind="net") %label1(label);
//   %wire2 @TEXT("\textbf{\textit{X}}_{\textbf{1}}", size=1.5116, bold=false, textcolor="#dc2626") => @PLACE(48.8, -16) => %label2;
//   $CANVAS_LABEL @ATTACH(bind="net") %label2(label);
//   %wire3 @TEXT("\textbf{\textit{X}}_{\textbf{2}}", size=1.5116, bold=false, textcolor="#dc2626") => @PLACE(58.8, -16) => %label3;
//   $CANVAS_LABEL @ATTACH(bind="net") %label3(label);
//   %wire4 @TEXT("\textbf{\textit{X}}_{\textbf{3}}", size=1.5116, bold=false, textcolor="#dc2626") => @PLACE(69.8, -10) => %label4;
//   $CANVAS_LABEL @ATTACH(bind="net") %label4(label);
//   %port28
//       @TEXT("\textbf{\textit{X}}_{\textbf{7}}", key="netname", dx=-1, dy=-0.5, halign="end", valign="baseline", size=1.5116,
//       bold=false, textvisible=true);
//   $CANVAS_LABEL @ATTACH(bind="port") %port28::netname(label);
//   %port29
//       @TEXT("\textbf{\textit{X}}_{\textbf{5}}", key="netname", dx=-1, dy=-0.5, halign="end", valign="baseline", size=1.5116,
//       bold=false, textvisible=true);
//   $CANVAS_LABEL @ATTACH(bind="port") %port29::netname(label);
//   %port30
//       @TEXT("\textbf{\textit{X}}_{\textbf{5}}", key="netname", dx=-1, dy=-1, halign="end", valign="baseline", size=1.5116,
//       bold=false, textvisible=true);
//   $CANVAS_LABEL @ATTACH(bind="port") %port30::netname(label);
//   %port31
//       @TEXT("\textbf{\textit{X}}_{\textbf{11}}", key="netname", dx=-1, dy=-0.5, halign="end", valign="baseline", size=1.5116,
//       bold=false, textvisible=true);
//   $CANVAS_LABEL @ATTACH(bind="port") %port31::netname(label);
//   %port32
//       @TEXT("\textbf{\textit{X}}_{\textbf{9}}", key="netname", dx=-1.5, dy=-0.5, halign="end", valign="baseline", size=1.5116,
//       bold=false, textvisible=true);
//   $CANVAS_LABEL @ATTACH(bind="port") %port32::netname(label);
//   %port33
//       @TEXT("\textbf{\textit{X}}_{\textbf{9}}", key="netname", dx=-1.5, dy=0, halign="end", valign="baseline", size=1.5116,
//       bold=false, textvisible=true);
//   $CANVAS_LABEL @ATTACH(bind="port") %port33::netname(label);
//   %port34
//       @TEXT("\textbf{\textit{X}}_{\textbf{8}}", key="netname", dx=-1, dy=-1.5, halign="end", valign="baseline", size=1.5116,
//       bold=false, textvisible=true);
//   $CANVAS_LABEL @ATTACH(bind="port") %port34::netname(label);
//   %port35
//       @TEXT("\textbf{\textit{X}}_{\textbf{9}}", key="netname", dx=-1.5, dy=-0.5, halign="end", valign="baseline", size=1.5116,
//       bold=false, textvisible=true);
//   $CANVAS_LABEL @ATTACH(bind="port") %port35::netname(label);
//   %port36
//       @TEXT("\textbf{\textit{X}}_{\textbf{10}}", key="netname", dx=-1.5, dy=0, halign="end", valign="baseline", size=1.5116,
//       bold=false, textvisible=true);
//   $CANVAS_LABEL @ATTACH(bind="port") %port36::netname(label);
//   %wire5 @TEXT("\textbf{\textit{X}}_{\textbf{4}}", size=1.5116, bold=false, textcolor="#dc2626") => @PLACE(81.8, -10) => %label5;
//   $CANVAS_LABEL @ATTACH(bind="net") %label5(label);
//   %wire6 @TEXT("\textbf{\textit{X}}_{\textbf{5}}", size=1.5116, bold=false, textcolor="#dc2626") => @PLACE(91.8, -17) => %label6;
//   $CANVAS_LABEL @ATTACH(bind="net") %label6(label);
//   %wire7 @TEXT("\textbf{\textit{X}}_{\textbf{6}}", size=1.5116, bold=false, textcolor="#dc2626") => @PLACE(101.8, -16) =>
//       %label7;
//   $CANVAS_LABEL @ATTACH(bind="net") %label7(label);
//   %wire8 @TEXT("\textbf{\textit{X}}_{\textbf{7}}", size=1.5116, bold=false, textcolor="#dc2626") => @PLACE(112.8, -10) =>
//       %label8;
//   $CANVAS_LABEL @ATTACH(bind="net") %label8(label);
//   %wire9 @TEXT("\textbf{\textit{X}}_{\textbf{8}}", size=1.5116, bold=false, textcolor="#dc2626") => @PLACE(123.8, -10) =>
//       %label9;
//   $CANVAS_LABEL @ATTACH(bind="net") %label9(label);
//   %wire10 @TEXT("\textbf{\textit{X}}_{\textbf{9}}", size=1.5116, bold=false, textcolor="#dc2626") => @PLACE(133.8, -16) =>
//       %label10;
//   $CANVAS_LABEL @ATTACH(bind="net") %label10(label);
//   %wire11 @TEXT("\textbf{\textit{X}}_{\textbf{10}}", size=1.5116, bold=false, textcolor="#dc2626") => @PLACE(143.8, -16) =>
//       %label11;
//   $CANVAS_LABEL @ATTACH(bind="net") %label11(label);
//   %wire12 @TEXT("\textbf{\textit{X}}_{\textbf{11}}", size=1.5116, bold=false, textcolor="#dc2626") => @PLACE(154.8, -10) =>
//       %label12;
//   $CANVAS_LABEL @ATTACH(bind="net") %label12(label);
//   #M37
//       @TEXT("\textbf{\textit{M}}_{\textbf{37}}", key="name", dx=-3, dy=1.5, halign="middle", valign="baseline", size=1.5116,
//       bold=false, textvisible=true);
//   $CANVAS_LABEL @ATTACH(bind="name") #M37::name(label);
//   #M38
//       @TEXT("\textbf{\textit{M}}_{\textbf{38}}", key="name", dx=-2.5, dy=-3, halign="middle", valign="baseline", size=1.5116,
//       bold=false, textvisible=true);
//   $CANVAS_LABEL @ATTACH(bind="name") #M38::name(label);
//   %port37
//       @TEXT("\textbf{\textit{CLK}}", key="netname", dx=0, dy=1.9, halign="middle", valign="baseline", size=1.5116, bold=false,
//       textvisible=true);
//   $CANVAS_LABEL @ATTACH(bind="port") %port37::netname(label);
//   %port38
//       @TEXT("\textbf{\textit{CLKB}}", key="netname", dx=0, dy=-2.8, halign="middle", valign="baseline", size=1.5116, bold=false,
//       textvisible=true);
//   $CANVAS_LABEL @ATTACH(bind="port") %port38::netname(label);
//   %port39
//       @TEXT("\textbf{\textit{D}}", key="netname", dx=-2, dy=-0.5, halign="end", valign="baseline", size=1.5116, bold=false,
//       textvisible=true);
//   $CANVAS_LABEL @ATTACH(bind="port") %port39::netname(label);
//   %port40
//       @TEXT("\textbf{\textit{Q}}", key="netname", dx=2, dy=-0.5, halign="start", valign="baseline", size=1.5116, bold=false,
//       textvisible=true);
//   $CANVAS_LABEL @ATTACH(bind="port") %port40::netname(label);
//   #M39
//       @TEXT("\textbf{\textit{M}}_{\textbf{39}}", key="name", dx=0.5, dy=-2.5, halign="start", valign="baseline", size=1.5116,
//       bold=false, textvisible=true);
//   $CANVAS_LABEL @ATTACH(bind="name") #M39::name(label);
//   #M40
//       @TEXT("\textbf{\textit{M}}_{\textbf{40}}", key="name", dx=1, dy=-2.5, halign="start", valign="baseline", size=1.5116,
//       bold=false, textvisible=true);
//   $CANVAS_LABEL @ATTACH(bind="name") #M40::name(label);
//   #M41
//       @TEXT("\textbf{\textit{M}}_{\textbf{41}}", key="name", dx=1, dy=-3, halign="start", valign="baseline", size=1.5116,
//       bold=false, textvisible=true);
//   $CANVAS_LABEL @ATTACH(bind="name") #M41::name(label);
//   #M42
//       @TEXT("\textbf{\textit{M}}_{\textbf{42}}", key="name", dx=0.5, dy=-2.5, halign="start", valign="baseline", size=1.5116,
//       bold=false, textvisible=true);
//   $CANVAS_LABEL @ATTACH(bind="name") #M42::name(label);
//   #M43
//       @TEXT("\textbf{\textit{M}}_{\textbf{43}}", key="name", dx=1, dy=-3, halign="start", valign="baseline", size=1.5116,
//       bold=false, textvisible=true);
//   $CANVAS_LABEL @ATTACH(bind="name") #M43::name(label);
//   #M44
//       @TEXT("\textbf{\textit{M}}_{\textbf{44}}", key="name", dx=1, dy=-3, halign="start", valign="baseline", size=1.5116,
//       bold=false, textvisible=true);
//   $CANVAS_LABEL @ATTACH(bind="name") #M44::name(label);
//   #M45
//       @TEXT("\textbf{\textit{M}}_{\textbf{45}}", key="name", dx=0.5, dy=-3, halign="start", valign="baseline", size=1.5116,
//       bold=false, textvisible=true);
//   $CANVAS_LABEL @ATTACH(bind="name") #M45::name(label);
//   #M46
//       @TEXT("\textbf{\textit{M}}_{\textbf{46}}", key="name", dx=1, dy=-3, halign="start", valign="baseline", size=1.5116,
//       bold=false, textvisible=true);
//   $CANVAS_LABEL @ATTACH(bind="name") #M46::name(label);
//   #M47
//       @TEXT("\textbf{\textit{M}}_{\textbf{47}}", key="name", dx=0.5, dy=-2, halign="start", valign="baseline", size=1.5116,
//       bold=false, textvisible=true);
//   $CANVAS_LABEL @ATTACH(bind="name") #M47::name(label);
//   #M48
//       @TEXT("\textbf{\textit{M}}_{\textbf{48}}", key="name", dx=1, dy=-2, halign="start", valign="baseline", size=1.5116,
//       bold=false, textvisible=true);
//   $CANVAS_LABEL @ATTACH(bind="name") #M48::name(label);
//   #M49
//       @TEXT("\textbf{\textit{M}}_{\textbf{49}}", key="name", dx=1, dy=-2.5, halign="start", valign="baseline", size=1.5116,
//       bold=false, textvisible=true);
//   $CANVAS_LABEL @ATTACH(bind="name") #M49::name(label);
//   #M50
//       @TEXT("\textbf{\textit{M}}_{\textbf{50}}", key="name", dx=1, dy=-2.5, halign="start", valign="baseline", size=1.5116,
//       bold=false, textvisible=true);
//   $CANVAS_LABEL @ATTACH(bind="name") #M50::name(label);
//   %port41
//       @TEXT("\textbf{\textit{CLK}}", key="netname", dx=-2, dy=-0.5, halign="end", valign="baseline", size=1.5116, bold=false,
//       textvisible=true);
//   $CANVAS_LABEL @ATTACH(bind="port") %port41::netname(label);
//   %wire13 @TEXT("\textbf{\textit{X}}_{\textbf{0}}", size=1.5116, bold=false) => @PLACE(39.5, -31) => %label13;
//   $CANVAS_LABEL @ATTACH(bind="net") %label13(label);
//   %wire14 @TEXT("\textbf{\textit{X}}_{\textbf{1}}", size=1.5116, bold=false) => @PLACE(46.5, -31) => %label14;
//   $CANVAS_LABEL @ATTACH(bind="net") %label14(label);
//   %wire15 @TEXT("\textbf{\textit{X}}_{\textbf{2}}", size=1.5116, bold=false) => @PLACE(53.5, -31) => %label15;
//   $CANVAS_LABEL @ATTACH(bind="net") %label15(label);
//   %wire16 @TEXT("\textbf{\textit{X}}_{\textbf{3}}", size=1.5116, bold=false) => @PLACE(60.5, -31) => %label16;
//   $CANVAS_LABEL @ATTACH(bind="net") %label16(label);
//   %wire17 @TEXT("\textbf{\textit{X}}_{\textbf{4}}", size=1.5116, bold=false) => @PLACE(67.5, -31) => %label17;
//   $CANVAS_LABEL @ATTACH(bind="net") %label17(label);
//   %wire18 @TEXT("\textbf{\textit{X}}_{\textbf{5}}", size=1.5116, bold=false) => @PLACE(74.5, -31) => %label18;
//   $CANVAS_LABEL @ATTACH(bind="net") %label18(label);
//   %wire19 @TEXT("\textbf{\textit{X}}_{\textbf{6}}", size=1.5116, bold=false) => @PLACE(81.5, -31) => %label19;
//   $CANVAS_LABEL @ATTACH(bind="net") %label19(label);
//   %wire20 @TEXT("\textbf{\textit{X}}_{\textbf{7}}", size=1.5116, bold=false) => @PLACE(88.5, -31) => %label20;
//   $CANVAS_LABEL @ATTACH(bind="net") %label20(label);
//   %wire21 @TEXT("\textbf{\textit{X}}_{\textbf{8}}", size=1.5116, bold=false) => @PLACE(95.5, -31) => %label21;
//   $CANVAS_LABEL @ATTACH(bind="net") %label21(label);
//   %wire22 @TEXT("\textbf{\textit{X}}_{\textbf{9}}", size=1.5116, bold=false) => @PLACE(102.5, -31) => %label22;
//   $CANVAS_LABEL @ATTACH(bind="net") %label22(label);
//   %wire23 @TEXT("\textbf{\textit{X}}_{\textbf{10}}", size=1.5116, bold=false) => @PLACE(109.5, -31) => %label23;
//   $CANVAS_LABEL @ATTACH(bind="net") %label23(label);
//   %wire24 @TEXT("\textbf{\textit{X}}_{\textbf{11}}", size=1.5116, bold=false) => @PLACE(116.5, -31) => %label24;
//   $CANVAS_LABEL @ATTACH(bind="net") %label24(label);
//   %wire25 @TEXT("\textbf{\textit{D}}", size=1.5116, bold=false) => @PLACE(41, -40) => %label25;
//   $CANVAS_LABEL @ATTACH(bind="net") %label25(label);
//   %wire26 @TEXT("\textbf{\textit{DN}}", size=1.5116, bold=false) => @PLACE(47.5, -43.5) => %label26;
//   $CANVAS_LABEL @ATTACH(bind="net") %label26(label);
//   #X1
//       @TEXT("\textbf{\textit{X}}_{\textbf{1}}", key="name", dx=-0.5, dy=-2.9, halign="middle", valign="baseline", size=1.5116,
//       bold=false, textvisible=true);
//   $CANVAS_LABEL @ATTACH(bind="name") #X1::name(label);
//   #X2
//       @TEXT("\textbf{\textit{X}}_{\textbf{2}}", key="name", dx=-0.5, dy=-2.9, halign="middle", valign="baseline", size=1.5116,
//       bold=false, textvisible=true);
//   $CANVAS_LABEL @ATTACH(bind="name") #X2::name(label);
//   %wire27 @TEXT("\textbf{\textit{D}}", size=1.5116, bold=false) => @PLACE(108, -62.6) => %label27;
//   $CANVAS_LABEL @ATTACH(bind="net") %label27(label);
//   %wire28 @TEXT("\textbf{\textit{DN}}", size=1.5116, bold=false) => @PLACE(117, -62.6) => %label28;
//   $CANVAS_LABEL @ATTACH(bind="net") %label28(label);
//   &CLK @TEXT("\textbf{\textit{CLK}}", size=1.5116, bold=false) => @PLACE(106.5, -70) => %label29;
//   $CANVAS_LABEL @ATTACH(bind="net") %label29(label);
//   %wire29 @TEXT("\textbf{\textit{CLKB}}", size=1.5116, bold=false) => @PLACE(116, -70.5) => %label30;
//   $CANVAS_LABEL @ATTACH(bind="net") %label30(label);
//   #M51
//       @TEXT("\textbf{\textit{M}}_{\textbf{51}}", key="name", dx=0.4, dy=-0.5, halign="start", valign="baseline", size=1.5116,
//       bold=false, textvisible=true);
//   $CANVAS_LABEL @ATTACH(bind="name") #M51::name(label);
//   #M52
//       @TEXT("\textbf{\textit{M}}_{\textbf{52}}", key="name", dx=0.4, dy=-0.5, halign="start", valign="baseline", size=1.5116,
//       bold=false, textvisible=true);
//   $CANVAS_LABEL @ATTACH(bind="name") #M52::name(label);
//   #M53
//       @TEXT("\textbf{\textit{M}}_{\textbf{53}}", key="name", dx=0.5, dy=-0.5, halign="start", valign="baseline", size=1.5116,
//       bold=false, textvisible=true);
//   $CANVAS_LABEL @ATTACH(bind="name") #M53::name(label);
//   #M54
//       @TEXT("\textbf{\textit{M}}_{\textbf{54}}", key="name", dx=0.5, dy=-0.5, halign="start", valign="baseline", size=1.5116,
//       bold=false, textvisible=true);
//   $CANVAS_LABEL @ATTACH(bind="name") #M54::name(label);
//   %vdd4 @TEXT("\textbf{\textit{V}}_{\textbf{DD}}", dx=2, dy=1, size=1.5116, bold=false) => %power4;
//   $CANVAS_LABEL @ATTACH(bind="port") %power4(label);
//   %wire30 @TEXT("\textbf{\textit{X}}_{\textbf{3}}", size=1.5116, bold=false) => @PLACE(33.8, -54) => %label31;
//   $CANVAS_LABEL @ATTACH(bind="net") %label31(label);
//   &X5 @TEXT("\textbf{\textit{X}}_{\textbf{5}}", size=1.5116, bold=false) => @PLACE(33.5, -60) => %label32;
//   $CANVAS_LABEL @ATTACH(bind="net") %label32(label);
//   #M55
//       @TEXT("\textbf{\textit{M}}_{\textbf{55}}", key="name", dx=0.4, dy=-0.5, halign="start", valign="baseline", size=1.5116,
//       bold=false, textvisible=true);
//   $CANVAS_LABEL @ATTACH(bind="name") #M55::name(label);
//   #M56
//       @TEXT("\textbf{\textit{M}}_{\textbf{56}}", key="name", dx=0.5, dy=0.5, halign="start", valign="baseline", size=1.5116,
//       bold=false, textvisible=true);
//   $CANVAS_LABEL @ATTACH(bind="name") #M56::name(label);
//   #M57
//       @TEXT("\textbf{\textit{M}}_{\textbf{57}}", key="name", dx=0.5, dy=-0.5, halign="start", valign="baseline", size=1.5116,
//       bold=false, textvisible=true);
//   $CANVAS_LABEL @ATTACH(bind="name") #M57::name(label);
//   #M58
//       @TEXT("\textbf{\textit{M}}_{\textbf{58}}", key="name", dx=0.5, dy=-0.5, halign="start", valign="baseline", size=1.5116,
//       bold=false, textvisible=true);
//   $CANVAS_LABEL @ATTACH(bind="name") #M58::name(label);
//   %vdd5 @TEXT("\textbf{\textit{V}}_{\textbf{DD}}", dx=2, dy=1, size=1.5116, bold=false) => %power5;
//   $CANVAS_LABEL @ATTACH(bind="port") %power5(label);
//   %wire31 @TEXT("\textbf{\textit{X}}_{\textbf{7}}", size=1.5116, bold=false) => @PLACE(46.8, -54) => %label33;
//   $CANVAS_LABEL @ATTACH(bind="net") %label33(label);
//   &X9 @TEXT("\textbf{\textit{X}}_{\textbf{9}}", size=1.5116, bold=false) => @PLACE(46.5, -60) => %label34;
//   $CANVAS_LABEL @ATTACH(bind="net") %label34(label);
//   #M59
//       @TEXT("\textbf{\textit{M}}_{\textbf{59}}", key="name", dx=0.4, dy=-0.5, halign="start", valign="baseline", size=1.5116,
//       bold=false, textvisible=true);
//   $CANVAS_LABEL @ATTACH(bind="name") #M59::name(label);
//   #M60
//       @TEXT("\textbf{\textit{M}}_{\textbf{60}}", key="name", dx=0.4, dy=-0.5, halign="start", valign="baseline", size=1.5116,
//       bold=false, textvisible=true);
//   $CANVAS_LABEL @ATTACH(bind="name") #M60::name(label);
//   #M61
//       @TEXT("\textbf{\textit{M}}_{\textbf{61}}", key="name", dx=0.5, dy=-0.5, halign="start", valign="baseline", size=1.5116,
//       bold=false, textvisible=true);
//   $CANVAS_LABEL @ATTACH(bind="name") #M61::name(label);
//   #M62
//       @TEXT("\textbf{\textit{M}}_{\textbf{62}}", key="name", dx=0.5, dy=-0.5, halign="start", valign="baseline", size=1.5116,
//       bold=false, textvisible=true);
//   $CANVAS_LABEL @ATTACH(bind="name") #M62::name(label);
//   %vdd6 @TEXT("\textbf{\textit{V}}_{\textbf{DD}}", dx=2, dy=1, size=1.5116, bold=false) => %power6;
//   $CANVAS_LABEL @ATTACH(bind="port") %power6(label);
//   %wire32 @TEXT("\textbf{\textit{X}}_{\textbf{11}}", size=1.5116, bold=false) => @PLACE(58.8, -54) => %label35;
//   $CANVAS_LABEL @ATTACH(bind="net") %label35(label);
//   &X1 @TEXT("\textbf{\textit{X}}_{\textbf{1}}", size=1.5116, bold=false) => @PLACE(58.5, -60) => %label36;
//   $CANVAS_LABEL @ATTACH(bind="net") %label36(label);
//   #M63
//       @TEXT("\textbf{\textit{M}}_{\textbf{63}}", key="name", dx=0.4, dy=-0.5, halign="start", valign="baseline", size=1.5116,
//       bold=false, textvisible=true);
//   $CANVAS_LABEL @ATTACH(bind="name") #M63::name(label);
//   #M64
//       @TEXT("\textbf{\textit{M}}_{\textbf{64}}", key="name", dx=0.4, dy=-0.5, halign="start", valign="baseline", size=1.5116,
//       bold=false, textvisible=true);
//   $CANVAS_LABEL @ATTACH(bind="name") #M64::name(label);
//   #M65
//       @TEXT("\textbf{\textit{M}}_{\textbf{65}}", key="name", dx=0.5, dy=-0.5, halign="start", valign="baseline", size=1.5116,
//       bold=false, textvisible=true);
//   $CANVAS_LABEL @ATTACH(bind="name") #M65::name(label);
//   #M66
//       @TEXT("\textbf{\textit{M}}_{\textbf{66}}", key="name", dx=0.5, dy=-0.5, halign="start", valign="baseline", size=1.5116,
//       bold=false, textvisible=true);
//   $CANVAS_LABEL @ATTACH(bind="name") #M66::name(label);
//   %vdd7 @TEXT("\textbf{\textit{V}}_{\textbf{DD}}", dx=2, dy=1, size=1.5116, bold=false) => %power7;
//   $CANVAS_LABEL @ATTACH(bind="port") %power7(label);
//   %wire33 @TEXT("\textbf{\textit{X}}_{\textbf{12}}", size=1.5116, bold=false) => @PLACE(72.5, -54) => %label37;
//   $CANVAS_LABEL @ATTACH(bind="net") %label37(label);
//   &X13 @TEXT("\textbf{\textit{X}}_{\textbf{13}}", size=1.5116, bold=false) => @PLACE(73, -64.5) => %label38;
//   $CANVAS_LABEL @ATTACH(bind="net") %label38(label);
//   #M67
//       @TEXT("\textbf{\textit{M}}_{\textbf{67}}", key="name", dx=0.4, dy=-0.5, halign="start", valign="baseline", size=1.5116,
//       bold=false, textvisible=true);
//   $CANVAS_LABEL @ATTACH(bind="name") #M67::name(label);
//   #M68
//       @TEXT("\textbf{\textit{M}}_{\textbf{68}}", key="name", dx=0.4, dy=-0.5, halign="start", valign="baseline", size=1.5116,
//       bold=false, textvisible=true);
//   $CANVAS_LABEL @ATTACH(bind="name") #M68::name(label);
//   #M69
//       @TEXT("\textbf{\textit{M}}_{\textbf{69}}", key="name", dx=0.5, dy=-0.5, halign="start", valign="baseline", size=1.5116,
//       bold=false, textvisible=true);
//   $CANVAS_LABEL @ATTACH(bind="name") #M69::name(label);
//   #M70
//       @TEXT("\textbf{\textit{M}}_{\textbf{70}}", key="name", dx=0.5, dy=-0.5, halign="start", valign="baseline", size=1.5116,
//       bold=false, textvisible=true);
//   $CANVAS_LABEL @ATTACH(bind="name") #M70::name(label);
//   %vdd8 @TEXT("\textbf{\textit{V}}_{\textbf{DD}}", dx=2, dy=1, size=1.5116, bold=false) => %power8;
//   $CANVAS_LABEL @ATTACH(bind="port") %power8(label);
//   %wire34 @TEXT("\textbf{\textit{X}}_{\textbf{13}}", size=1.5116, bold=false) => @PLACE(84.5, -54) => %label39;
//   $CANVAS_LABEL @ATTACH(bind="net") %label39(label);
//   &X14 @TEXT("\textbf{\textit{X}}_{\textbf{14}}", size=1.5116, bold=false) => @PLACE(85, -64.5) => %label40;
//   $CANVAS_LABEL @ATTACH(bind="net") %label40(label);
//   #M71
//       @TEXT("\textbf{\textit{M}}_{\textbf{71}}", key="name", dx=0.4, dy=-0.5, halign="start", valign="baseline", size=1.5116,
//       bold=false, textvisible=true);
//   $CANVAS_LABEL @ATTACH(bind="name") #M71::name(label);
//   #M72
//       @TEXT("\textbf{\textit{M}}_{\textbf{72}}", key="name", dx=0.4, dy=-0.5, halign="start", valign="baseline", size=1.5116,
//       bold=false, textvisible=true);
//   $CANVAS_LABEL @ATTACH(bind="name") #M72::name(label);
//   #M73
//       @TEXT("\textbf{\textit{M}}_{\textbf{73}}", key="name", dx=0.4, dy=-0.5, halign="start", valign="baseline", size=1.5116,
//       bold=false, textvisible=true);
//   $CANVAS_LABEL @ATTACH(bind="name") #M73::name(label);
//   #M74
//       @TEXT("\textbf{\textit{M}}_{\textbf{74}}", key="name", dx=0.5, dy=-0.5, halign="start", valign="baseline", size=1.5116,
//       bold=false, textvisible=true);
//   $CANVAS_LABEL @ATTACH(bind="name") #M74::name(label);
//   #M75
//       @TEXT("\textbf{\textit{M}}_{\textbf{75}}", key="name", dx=0.5, dy=-0.5, halign="start", valign="baseline", size=1.5116,
//       bold=false, textvisible=true);
//   $CANVAS_LABEL @ATTACH(bind="name") #M75::name(label);
//   #M76
//       @TEXT("\textbf{\textit{M}}_{\textbf{76}}", key="name", dx=0.5, dy=-0.5, halign="start", valign="baseline", size=1.5116,
//       bold=false, textvisible=true);
//   $CANVAS_LABEL @ATTACH(bind="name") #M76::name(label);
//   %vdd9 @TEXT("\textbf{\textit{V}}_{\textbf{DD}}", dx=2, dy=1, size=1.5116, bold=false) => %power9;
//   $CANVAS_LABEL @ATTACH(bind="port") %power9(label);
//   &X15 @TEXT("\textbf{\textit{X}}_{\textbf{15}}", size=1.5116, bold=false) => @PLACE(125.5, -52.5) => %label41;
//   $CANVAS_LABEL @ATTACH(bind="net") %label41(label);
//   %wire35 @TEXT("\textbf{\textit{X16}}", size=1.5116, bold=false) => @PLACE(131.5, -50.5) => %label42;
//   $CANVAS_LABEL @ATTACH(bind="net") %label42(label);
//   %port42
//       @TEXT("\textbf{\textit{CLK}}", key="netname", dx=-0.5, dy=1, halign="end", valign="baseline", size=1.5116, bold=false,
//       textvisible=true);
//   $CANVAS_LABEL @ATTACH(bind="port") %port42::netname(label);
//   %port43
//       @TEXT("\textbf{\textit{CLKB}}", key="netname", dx=0.5, dy=-2.5, halign="end", valign="baseline", size=1.5116, bold=false,
//       textvisible=true);
//   $CANVAS_LABEL @ATTACH(bind="port") %port43::netname(label);
//   &X12 @TEXT("\textbf{\textit{X12}}", size=1.5116, bold=false, textcolor="#059669") => @PLACE(42.5, -60.5) => %label43;
//   $CANVAS_LABEL @ATTACH(bind="net") %label43(label);
//   %wire36 @TEXT("\textbf{\textit{X13}}", size=1.5116, bold=false, textcolor="#059669") => @PLACE(54.5, -59.5) => %label44;
//   $CANVAS_LABEL @ATTACH(bind="net") %label44(label);
//   %wire37 @TEXT("\textbf{\textit{X14}}", size=1.5116, bold=false, textcolor="#059669") => @PLACE(67, -59.6) => %label45;
//   $CANVAS_LABEL @ATTACH(bind="net") %label45(label);
//   %wire38 @TEXT("\textbf{\textit{X15}}", size=1.5116, bold=false, textcolor="#059669") => @PLACE(81, -59.6) => %label46;
//   $CANVAS_LABEL @ATTACH(bind="net") %label46(label);
//   &X16 @TEXT("\textbf{\textit{X16}}", size=1.5116, bold=false, textcolor="#059669") => @PLACE(93.5, -60.5) => %label47;
//   $CANVAS_LABEL @ATTACH(bind="net") %label47(label);
//   &Q @TEXT("\textbf{\textit{Q}}", size=1.5116, bold=false, textcolor="#059669") => @PLACE(141.5, -50) => %label48;
//   $CANVAS_LABEL @ATTACH(bind="net") %label48(label);
//   %vdd1 @TEXT("${p}", key="netname", textvisible=false);
//   %vdd2 @TEXT("${p}", key="netname", textvisible=false);
//   %vdd3 @TEXT("${p}", key="netname", textvisible=false);
//   %vdd4 @TEXT("${p}", key="netname", textvisible=false);
//   %vdd5 @TEXT("${p}", key="netname", textvisible=false);
//   %vdd6 @TEXT("${p}", key="netname", textvisible=false);
//   %vdd7 @TEXT("${p}", key="netname", textvisible=false);
//   %vdd8 @TEXT("${p}", key="netname", textvisible=false);
//   %vdd9 @TEXT("${p}", key="netname", textvisible=false)
// }
ends dut
