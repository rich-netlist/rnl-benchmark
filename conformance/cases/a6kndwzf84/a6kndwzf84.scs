simulator lang=spectre
// @RNL(type="header") {
//   @VERSION("0.4");
//   @USE-PACKAGE(name="rnl-std-style", version="0.4");
//   @USE-PACKAGE(name="rnl-std-basic", version="0.4");
//   @USE-PACKAGE(name="rnl-std-semiconductors", version="0.4");
//   @USE-PACKAGE(name="rnl-std-no-labels", version="0.4");
//   @USE-PACKAGE(name="analog-canvas-extensions", version="0.7")
// }

subckt astra_051_cmos_dcvsl_word_equality (vdd VSS eq ne a0 a1 b0 b1)
CE (eq VSS) capacitor c=100f
CN (ne VSS) capacitor c=100f
M1 (eq ne vdd vdd) APMOS l=1u w=5u
M10 (b1b b1 VSS VSS) ANMOS l=1u w=10u
M11 (eq a0 net5 VSS) ANMOS l=1u w=10u
M12 (net5 b0b VSS VSS) ANMOS l=1u w=10u
M13 (eq a0b net6 VSS) ANMOS l=1u w=10u
M14 (net6 b0 VSS VSS) ANMOS l=1u w=10u
M15 (eq a1 net7 VSS) ANMOS l=1u w=10u
M16 (net7 b1b VSS VSS) ANMOS l=1u w=10u
M17 (eq a1b net8 VSS) ANMOS l=1u w=10u
M18 (net8 b1 VSS VSS) ANMOS l=1u w=10u
M19 (ne a0 net0 VSS) ANMOS l=1u w=10u
M2 (ne eq vdd vdd) APMOS l=1u w=5u
M20 (net0 b0 net4 VSS) ANMOS l=1u w=10u
M21 (ne a0b net1 VSS) ANMOS l=1u w=10u
M22 (net1 b0b net4 VSS) ANMOS l=1u w=10u
M23 (net4 a1 net2 VSS) ANMOS l=1u w=10u
M24 (net2 b1 VSS VSS) ANMOS l=1u w=10u
M25 (net4 a1b net3 VSS) ANMOS l=1u w=10u
M26 (net3 b1b VSS VSS) ANMOS l=1u w=10u
M3 (a0b a0 vdd vdd) APMOS l=1u w=20u
M4 (a0b a0 VSS VSS) ANMOS l=1u w=10u
M5 (a1b a1 vdd vdd) APMOS l=1u w=20u
M6 (a1b a1 VSS VSS) ANMOS l=1u w=10u
M7 (b0b b0 vdd vdd) APMOS l=1u w=20u
M8 (b0b b0 VSS VSS) ANMOS l=1u w=10u
M9 (b1b b1 vdd vdd) APMOS l=1u w=20u
// @RNL(author="analog-canvas") {
//   $CANVAS_TYPESETTING @ATTACH(subscript_italic=false, subscript_after_first=true) #(level);
//   #M1 @SET-SYMBOL(terminals=[[1, "d"], [2, "g"], [3, "s"], [4, "b"]]) $CANVAS_PMOS_4TERM => @PLACE(35, 0) => @ORIENT("MY");
//   #M2 @SET-SYMBOL(terminals=[[1, "d"], [2, "g"], [3, "s"], [4, "b"]]) $CANVAS_PMOS_4TERM => @PLACE(83, 0) => @ORIENT("R0");
//   $SUPPLY @ATTACH &vdd(p) => @SET-SYMBOL $SUPPLY_SYMBOL => @PLACE(35, 3) => @ORIENT("R0") => %vdd1;
//   $SUPPLY @ATTACH &vdd(p) => @SET-SYMBOL $SUPPLY_SYMBOL => @PLACE(83, 3) => @ORIENT("R0") => %vdd2;
//   #M11 @SET-SYMBOL(terminals=[[1, "d"], [2, "g"], [3, "s"], [4, "b"]]) $CANVAS_NMOS_4TERM => @PLACE(13, -17) => @ORIENT("R0");
//   #M12 @SET-SYMBOL(terminals=[[1, "d"], [2, "g"], [3, "s"], [4, "b"]]) $CANVAS_NMOS_4TERM => @PLACE(13, -23) => @ORIENT("R0");
//   $GROUND @ATTACH &VSS(p) => @SET-SYMBOL $GROUND_SYMBOL => @PLACE(13, -26) => @ORIENT("R0") => %gnd1;
//   #M13 @SET-SYMBOL(terminals=[[1, "d"], [2, "g"], [3, "s"], [4, "b"]]) $CANVAS_NMOS_4TERM => @PLACE(27, -17) => @ORIENT("R0");
//   #M14 @SET-SYMBOL(terminals=[[1, "d"], [2, "g"], [3, "s"], [4, "b"]]) $CANVAS_NMOS_4TERM => @PLACE(27, -23) => @ORIENT("R0");
//   $GROUND @ATTACH &VSS(p) => @SET-SYMBOL $GROUND_SYMBOL => @PLACE(27, -26) => @ORIENT("R0") => %gnd2;
//   #M15 @SET-SYMBOL(terminals=[[1, "d"], [2, "g"], [3, "s"], [4, "b"]]) $CANVAS_NMOS_4TERM => @PLACE(41, -17) => @ORIENT("R0");
//   #M16 @SET-SYMBOL(terminals=[[1, "d"], [2, "g"], [3, "s"], [4, "b"]]) $CANVAS_NMOS_4TERM => @PLACE(41, -23) => @ORIENT("R0");
//   $GROUND @ATTACH &VSS(p) => @SET-SYMBOL $GROUND_SYMBOL => @PLACE(41, -26) => @ORIENT("R0") => %gnd3;
//   #M17 @SET-SYMBOL(terminals=[[1, "d"], [2, "g"], [3, "s"], [4, "b"]]) $CANVAS_NMOS_4TERM => @PLACE(55, -17) => @ORIENT("R0");
//   #M18 @SET-SYMBOL(terminals=[[1, "d"], [2, "g"], [3, "s"], [4, "b"]]) $CANVAS_NMOS_4TERM => @PLACE(55, -23) => @ORIENT("R0");
//   $GROUND @ATTACH &VSS(p) => @SET-SYMBOL $GROUND_SYMBOL => @PLACE(55, -26) => @ORIENT("R0") => %gnd4;
//   #CE @SET-SYMBOL $CAPACITOR => @PLACE(64, -20) => @ORIENT("R0");
//   $GROUND @ATTACH &VSS(p) => @SET-SYMBOL $GROUND_SYMBOL => @PLACE(64, -23) => @ORIENT("R0") => %gnd5;
//   $IO_PORT @ATTACH &eq(p) => @SET-SYMBOL $IO_PORT_SYMBOL => @PLACE(66, -10) => @ORIENT("MY") => %port1;
//   #M19 @SET-SYMBOL(terminals=[[1, "d"], [2, "g"], [3, "s"], [4, "b"]]) $CANVAS_NMOS_4TERM => @PLACE(79, -17) => @ORIENT("R0");
//   #M20 @SET-SYMBOL(terminals=[[1, "d"], [2, "g"], [3, "s"], [4, "b"]]) $CANVAS_NMOS_4TERM => @PLACE(79, -23) => @ORIENT("R0");
//   #M21 @SET-SYMBOL(terminals=[[1, "d"], [2, "g"], [3, "s"], [4, "b"]]) $CANVAS_NMOS_4TERM => @PLACE(95, -17) => @ORIENT("R0");
//   #M22 @SET-SYMBOL(terminals=[[1, "d"], [2, "g"], [3, "s"], [4, "b"]]) $CANVAS_NMOS_4TERM => @PLACE(95, -23) => @ORIENT("R0");
//   #M23 @SET-SYMBOL(terminals=[[1, "d"], [2, "g"], [3, "s"], [4, "b"]]) $CANVAS_NMOS_4TERM => @PLACE(79, -32) => @ORIENT("R0");
//   #M24 @SET-SYMBOL(terminals=[[1, "d"], [2, "g"], [3, "s"], [4, "b"]]) $CANVAS_NMOS_4TERM => @PLACE(79, -38) => @ORIENT("R0");
//   $GROUND @ATTACH &VSS(p) => @SET-SYMBOL $GROUND_SYMBOL => @PLACE(79, -41) => @ORIENT("R0") => %gnd6;
//   #M25 @SET-SYMBOL(terminals=[[1, "d"], [2, "g"], [3, "s"], [4, "b"]]) $CANVAS_NMOS_4TERM => @PLACE(95, -32) => @ORIENT("R0");
//   #M26 @SET-SYMBOL(terminals=[[1, "d"], [2, "g"], [3, "s"], [4, "b"]]) $CANVAS_NMOS_4TERM => @PLACE(95, -38) => @ORIENT("R0");
//   $GROUND @ATTACH &VSS(p) => @SET-SYMBOL $GROUND_SYMBOL => @PLACE(95, -41) => @ORIENT("R0") => %gnd7;
//   #CN @SET-SYMBOL $CAPACITOR => @PLACE(106, -19) => @ORIENT("R0");
//   $GROUND @ATTACH &VSS(p) => @SET-SYMBOL $GROUND_SYMBOL => @PLACE(106, -22) => @ORIENT("R0") => %gnd8;
//   $IO_PORT @ATTACH &ne(p) => @SET-SYMBOL $IO_PORT_SYMBOL => @PLACE(108, -10) => @ORIENT("MY") => %port2;
//   #M3 @SET-SYMBOL(terminals=[[1, "d"], [2, "g"], [3, "s"], [4, "b"]]) $CANVAS_PMOS_4TERM => @PLACE(13, -39) => @ORIENT("R0");
//   #M4 @SET-SYMBOL(terminals=[[1, "d"], [2, "g"], [3, "s"], [4, "b"]]) $CANVAS_NMOS_4TERM => @PLACE(13, -47) => @ORIENT("R0");
//   $SUPPLY @ATTACH &vdd(p) => @SET-SYMBOL $SUPPLY_SYMBOL => @PLACE(13, -36) => @ORIENT("R0") => %vdd3;
//   $GROUND @ATTACH &VSS(p) => @SET-SYMBOL $GROUND_SYMBOL => @PLACE(13, -50) => @ORIENT("R0") => %gnd9;
//   $IO_PORT @ATTACH &a0(p) => @SET-SYMBOL $IO_PORT_SYMBOL => @PLACE(8, -43) => @ORIENT("R0") => %port3;
//   #M5 @SET-SYMBOL(terminals=[[1, "d"], [2, "g"], [3, "s"], [4, "b"]]) $CANVAS_PMOS_4TERM => @PLACE(30, -39) => @ORIENT("R0");
//   #M6 @SET-SYMBOL(terminals=[[1, "d"], [2, "g"], [3, "s"], [4, "b"]]) $CANVAS_NMOS_4TERM => @PLACE(30, -47) => @ORIENT("R0");
//   $SUPPLY @ATTACH &vdd(p) => @SET-SYMBOL $SUPPLY_SYMBOL => @PLACE(30, -36) => @ORIENT("R0") => %vdd4;
//   $GROUND @ATTACH &VSS(p) => @SET-SYMBOL $GROUND_SYMBOL => @PLACE(30, -50) => @ORIENT("R0") => %gnd10;
//   $IO_PORT @ATTACH &a1(p) => @SET-SYMBOL $IO_PORT_SYMBOL => @PLACE(25, -43) => @ORIENT("R0") => %port4;
//   #M7 @SET-SYMBOL(terminals=[[1, "d"], [2, "g"], [3, "s"], [4, "b"]]) $CANVAS_PMOS_4TERM => @PLACE(47, -39) => @ORIENT("R0");
//   #M8 @SET-SYMBOL(terminals=[[1, "d"], [2, "g"], [3, "s"], [4, "b"]]) $CANVAS_NMOS_4TERM => @PLACE(47, -47) => @ORIENT("R0");
//   $SUPPLY @ATTACH &vdd(p) => @SET-SYMBOL $SUPPLY_SYMBOL => @PLACE(47, -36) => @ORIENT("R0") => %vdd5;
//   $GROUND @ATTACH &VSS(p) => @SET-SYMBOL $GROUND_SYMBOL => @PLACE(47, -50) => @ORIENT("R0") => %gnd11;
//   $IO_PORT @ATTACH &b0(p) => @SET-SYMBOL $IO_PORT_SYMBOL => @PLACE(42, -43) => @ORIENT("R0") => %port5;
//   #M9 @SET-SYMBOL(terminals=[[1, "d"], [2, "g"], [3, "s"], [4, "b"]]) $CANVAS_PMOS_4TERM => @PLACE(64, -39) => @ORIENT("R0");
//   #M10 @SET-SYMBOL(terminals=[[1, "d"], [2, "g"], [3, "s"], [4, "b"]]) $CANVAS_NMOS_4TERM => @PLACE(64, -47) => @ORIENT("R0");
//   $SUPPLY @ATTACH &vdd(p) => @SET-SYMBOL $SUPPLY_SYMBOL => @PLACE(64, -36) => @ORIENT("R0") => %vdd6;
//   $GROUND @ATTACH &VSS(p) => @SET-SYMBOL $GROUND_SYMBOL => @PLACE(64, -50) => @ORIENT("R0") => %gnd12;
//   $IO_PORT @ATTACH &b1(p) => @SET-SYMBOL $IO_PORT_SYMBOL => @PLACE(59, -43) => @ORIENT("R0") => %port6;
//   %j1 = (35, -8);
//   %j2 = (35, -10);
//   %j3 = (74, -8);
//   %j4 = (74, 0);
//   %j5 = (83, -6);
//   %j6 = (83, -10);
//   %j7 = (44, -6);
//   %j8 = (44, 0);
//   %j9 = (13, -10);
//   %j10 = (9, -17);
//   %j11 = (9, -23);
//   %j12 = (27, -10);
//   %j13 = (23, -17);
//   %j14 = (23, -23);
//   %j15 = (41, -10);
//   %j16 = (37, -17);
//   %j17 = (37, -23);
//   %j18 = (55, -10);
//   %j19 = (51, -17);
//   %j20 = (51, -23);
//   %j21 = (64, -10);
//   %j22 = (75, -17);
//   %j23 = (75, -23);
//   %j24 = (91, -17);
//   %j25 = (91, -23);
//   %j26 = (75, -32);
//   %j27 = (75, -38);
//   %j28 = (91, -32);
//   %j29 = (91, -38);
//   %j30 = (79, -10);
//   %j31 = (95, -10);
//   %j32 = (106, -10);
//   %j33 = (79, -28);
//   %j34 = (95, -28);
//   %j35 = (9, -39);
//   %j36 = (9, -43);
//   %j37 = (9, -47);
//   %j38 = (13, -43);
//   %j39 = (15, -43);
//   %j40 = (26, -39);
//   %j41 = (26, -43);
//   %j42 = (26, -47);
//   %j43 = (30, -43);
//   %j44 = (32, -43);
//   %j45 = (43, -39);
//   %j46 = (43, -43);
//   %j47 = (43, -47);
//   %j48 = (47, -43);
//   %j49 = (49, -43);
//   %j50 = (60, -39);
//   %j51 = (60, -43);
//   %j52 = (60, -47);
//   %j53 = (64, -43);
//   %j54 = (66, -43);
//   &vdd @WIRE(mode="straight") {%vdd1::pin #M1:3};
//   &vdd @WIRE(mode="straight") {%vdd2::pin #M2:3};
//   &eq @WIRE(mode="straight") {#M1:1 %j1};
//   &eq @WIRE(mode="straight") {%j1 %j2};
//   &eq @WIRE(mode="straight") {%j1 %j3};
//   &eq @WIRE(mode="straight") {%j3 %j4};
//   &eq @WIRE(mode="straight") {%j4 #M2:2};
//   &ne @WIRE(mode="straight") {#M2:1 %j5};
//   &ne @WIRE(mode="straight") {%j5 %j6};
//   &ne @WIRE(mode="straight") {%j5 %j7};
//   &ne @WIRE(mode="straight") {%j7 %j8};
//   &ne @WIRE(mode="straight") {%j8 #M1:2};
//   &net5 @WIRE(mode="straight") {#M11:3 #M12:1};
//   &VSS @WIRE(mode="straight") {#M12:3 %gnd1::pin};
//   &eq @WIRE(mode="straight") {%j9 #M11:1};
//   &a0 @WIRE(mode="straight") {#M11:2 %j10};
//   &b0b @WIRE(mode="straight") {#M12:2 %j11};
//   &net6 @WIRE(mode="straight") {#M13:3 #M14:1};
//   &VSS @WIRE(mode="straight") {#M14:3 %gnd2::pin};
//   &eq @WIRE(mode="straight") {%j12 #M13:1};
//   &a0b @WIRE(mode="straight") {#M13:2 %j13};
//   &b0 @WIRE(mode="straight") {#M14:2 %j14};
//   &net7 @WIRE(mode="straight") {#M15:3 #M16:1};
//   &VSS @WIRE(mode="straight") {#M16:3 %gnd3::pin};
//   &eq @WIRE(mode="straight") {%j15 #M15:1};
//   &a1 @WIRE(mode="straight") {#M15:2 %j16};
//   &b1b @WIRE(mode="straight") {#M16:2 %j17};
//   &net8 @WIRE(mode="straight") {#M17:3 #M18:1};
//   &VSS @WIRE(mode="straight") {#M18:3 %gnd4::pin};
//   &eq @WIRE(mode="straight") {%j18 #M17:1};
//   &a1b @WIRE(mode="straight") {#M17:2 %j19};
//   &b1 @WIRE(mode="straight") {#M18:2 %j20};
//   &eq @WIRE(mode="straight") {%j9 %j12};
//   &eq @WIRE(mode="straight") {%j12 %j2};
//   &eq @WIRE(mode="straight") {%j2 %j15};
//   &eq @WIRE(mode="straight") {%j15 %j18};
//   &eq @WIRE(mode="straight") {%j18 %j21};
//   &VSS @WIRE(mode="straight") {#CE:2 %gnd5::pin};
//   &eq @WIRE(mode="straight") {%j21 #CE:1};
//   &eq @WIRE(mode="straight") {%j21 %port1::pin};
//   &net0 @WIRE(mode="straight") {#M19:3 #M20:1};
//   &a0 @WIRE(mode="straight") {#M19:2 %j22};
//   &b0 @WIRE(mode="straight") {#M20:2 %j23};
//   &net1 @WIRE(mode="straight") {#M21:3 #M22:1};
//   &a0b @WIRE(mode="straight") {#M21:2 %j24};
//   &b0b @WIRE(mode="straight") {#M22:2 %j25};
//   &net2 @WIRE(mode="straight") {#M23:3 #M24:1};
//   &a1 @WIRE(mode="straight") {#M23:2 %j26};
//   &b1 @WIRE(mode="straight") {#M24:2 %j27};
//   &VSS @WIRE(mode="straight") {#M24:3 %gnd6::pin};
//   &net3 @WIRE(mode="straight") {#M25:3 #M26:1};
//   &a1b @WIRE(mode="straight") {#M25:2 %j28};
//   &b1b @WIRE(mode="straight") {#M26:2 %j29};
//   &VSS @WIRE(mode="straight") {#M26:3 %gnd7::pin};
//   &ne @WIRE(mode="straight") {%j30 %j6};
//   &ne @WIRE(mode="straight") {%j6 %j31};
//   &ne @WIRE(mode="straight") {%j31 %j32};
//   &ne @WIRE(mode="straight") {%j30 #M19:1};
//   &ne @WIRE(mode="straight") {%j31 #M21:1};
//   &net4 @WIRE(mode="straight") {#M20:3 %j33};
//   &net4 @WIRE(mode="straight") {%j33 %j34};
//   &net4 @WIRE(mode="straight") {%j34 #M22:3};
//   &net4 @WIRE(mode="straight") {%j33 #M23:1};
//   &net4 @WIRE(mode="straight") {%j34 #M25:1};
//   &VSS @WIRE(mode="straight") {#CN:2 %gnd8::pin};
//   &ne @WIRE(mode="straight") {%j32 #CN:1};
//   &ne @WIRE(mode="straight") {%j32 %port2::pin};
//   &vdd @WIRE(mode="straight") {%vdd3::pin #M3:3};
//   &VSS @WIRE(mode="straight") {#M4:3 %gnd9::pin};
//   &a0 @WIRE(mode="straight") {#M3:2 %j35};
//   &a0 @WIRE(mode="straight") {%j35 %j36};
//   &a0 @WIRE(mode="straight") {%j36 %j37};
//   &a0 @WIRE(mode="straight") {%j37 #M4:2};
//   &a0b @WIRE(mode="straight") {#M3:1 %j38};
//   &a0b @WIRE(mode="straight") {%j38 #M4:1};
//   &a0 @WIRE(mode="straight") {%port3::pin %j36};
//   &a0b @WIRE(mode="straight") {%j38 %j39};
//   &vdd @WIRE(mode="straight") {%vdd4::pin #M5:3};
//   &VSS @WIRE(mode="straight") {#M6:3 %gnd10::pin};
//   &a1 @WIRE(mode="straight") {#M5:2 %j40};
//   &a1 @WIRE(mode="straight") {%j40 %j41};
//   &a1 @WIRE(mode="straight") {%j41 %j42};
//   &a1 @WIRE(mode="straight") {%j42 #M6:2};
//   &a1b @WIRE(mode="straight") {#M5:1 %j43};
//   &a1b @WIRE(mode="straight") {%j43 #M6:1};
//   &a1 @WIRE(mode="straight") {%port4::pin %j41};
//   &a1b @WIRE(mode="straight") {%j43 %j44};
//   &vdd @WIRE(mode="straight") {%vdd5::pin #M7:3};
//   &VSS @WIRE(mode="straight") {#M8:3 %gnd11::pin};
//   &b0 @WIRE(mode="straight") {#M7:2 %j45};
//   &b0 @WIRE(mode="straight") {%j45 %j46};
//   &b0 @WIRE(mode="straight") {%j46 %j47};
//   &b0 @WIRE(mode="straight") {%j47 #M8:2};
//   &b0b @WIRE(mode="straight") {#M7:1 %j48};
//   &b0b @WIRE(mode="straight") {%j48 #M8:1};
//   &b0 @WIRE(mode="straight") {%port5::pin %j46};
//   &b0b @WIRE(mode="straight") {%j48 %j49};
//   &vdd @WIRE(mode="straight") {%vdd6::pin #M9:3};
//   &VSS @WIRE(mode="straight") {#M10:3 %gnd12::pin};
//   &b1 @WIRE(mode="straight") {#M9:2 %j50};
//   &b1 @WIRE(mode="straight") {%j50 %j51};
//   &b1 @WIRE(mode="straight") {%j51 %j52};
//   &b1 @WIRE(mode="straight") {%j52 #M10:2};
//   &b1b @WIRE(mode="straight") {#M9:1 %j53};
//   &b1b @WIRE(mode="straight") {%j53 #M10:1};
//   &b1 @WIRE(mode="straight") {%port6::pin %j51};
//   &b1b @WIRE(mode="straight") {%j53 %j54};
//   $JUNCTION @ATTACH %j36(p) => @PLACE(9, -43) => %dot1;
//   $JUNCTION @ATTACH %j38(p) => @PLACE(13, -43) => %dot2;
//   $JUNCTION @ATTACH %j41(p) => @PLACE(26, -43) => %dot3;
//   $JUNCTION @ATTACH %j43(p) => @PLACE(30, -43) => %dot4;
//   $JUNCTION @ATTACH %j46(p) => @PLACE(43, -43) => %dot5;
//   $JUNCTION @ATTACH %j48(p) => @PLACE(47, -43) => %dot6;
//   $JUNCTION @ATTACH %j51(p) => @PLACE(60, -43) => %dot7;
//   $JUNCTION @ATTACH %j53(p) => @PLACE(64, -43) => %dot8;
//   $JUNCTION @ATTACH %j12(p) => @PLACE(27, -10) => %dot9;
//   $JUNCTION @ATTACH %j1(p) => @PLACE(35, -8) => %dot10;
//   $JUNCTION @ATTACH %j2(p) => @PLACE(35, -10) => %dot11;
//   $JUNCTION @ATTACH %j15(p) => @PLACE(41, -10) => %dot12;
//   $JUNCTION @ATTACH %j18(p) => @PLACE(55, -10) => %dot13;
//   $JUNCTION @ATTACH %j21(p) => @PLACE(64, -10) => %dot14;
//   $JUNCTION @ATTACH %j33(p) => @PLACE(79, -28) => %dot15;
//   $JUNCTION @ATTACH %j34(p) => @PLACE(95, -28) => %dot16;
//   $JUNCTION @ATTACH %j5(p) => @PLACE(83, -6) => %dot17;
//   $JUNCTION @ATTACH %j6(p) => @PLACE(83, -10) => %dot18;
//   $JUNCTION @ATTACH %j31(p) => @PLACE(95, -10) => %dot19;
//   $JUNCTION @ATTACH %j32(p) => @PLACE(106, -10) => %dot20;
//   #M1
//       @TEXT("\textbf{\textit{M}}_{\textbf{1}}", key="name", dx=-0.4, dy=-0.5, halign="end", valign="baseline", size=1.5116,
//       bold=false, textvisible=true);
//   $CANVAS_LABEL @ATTACH(bind="name") #M1::name(label);
//   #M2
//       @TEXT("\textbf{\textit{M}}_{\textbf{2}}", key="name", dx=0.4, dy=-0.5, halign="start", valign="baseline", size=1.5116,
//       bold=false, textvisible=true);
//   $CANVAS_LABEL @ATTACH(bind="name") #M2::name(label);
//   &vdd @TEXT("\textbf{\textit{v}}_{\textbf{dd}}", halign="middle", size=1.5116, bold=false) => @PLACE(35, 6) => %power1;
//   $CANVAS_LABEL @ATTACH(bind="net") %power1(label);
//   &vdd @TEXT("\textbf{\textit{v}}_{\textbf{dd}}", halign="middle", size=1.5116, bold=false) => @PLACE(83, 6) => %power2;
//   $CANVAS_LABEL @ATTACH(bind="net") %power2(label);
//   #M11
//       @TEXT("\textbf{\textit{M}}_{\textbf{11}}", key="name", dx=0.5, dy=-0.5, halign="start", valign="baseline", size=1.5116,
//       bold=false, textvisible=true);
//   $CANVAS_LABEL @ATTACH(bind="name") #M11::name(label);
//   #M12
//       @TEXT("\textbf{\textit{M}}_{\textbf{12}}", key="name", dx=0.5, dy=-0.5, halign="start", valign="baseline", size=1.5116,
//       bold=false, textvisible=true);
//   $CANVAS_LABEL @ATTACH(bind="name") #M12::name(label);
//   &a0 @TEXT("\textbf{\textit{a0}}", halign="end", size=1.5116, bold=false) => @PLACE(8, -17.4) => %label1;
//   $CANVAS_LABEL @ATTACH(bind="net") %label1(label);
//   &b0b @TEXT("\textbf{\textit{b0b}}", halign="end", size=1.5116, bold=false) => @PLACE(8, -23.4) => %label2;
//   $CANVAS_LABEL @ATTACH(bind="net") %label2(label);
//   #M13
//       @TEXT("\textbf{\textit{M}}_{\textbf{13}}", key="name", dx=0.5, dy=-0.5, halign="start", valign="baseline", size=1.5116,
//       bold=false, textvisible=true);
//   $CANVAS_LABEL @ATTACH(bind="name") #M13::name(label);
//   #M14
//       @TEXT("\textbf{\textit{M}}_{\textbf{14}}", key="name", dx=0.5, dy=-0.5, halign="start", valign="baseline", size=1.5116,
//       bold=false, textvisible=true);
//   $CANVAS_LABEL @ATTACH(bind="name") #M14::name(label);
//   &a0b @TEXT("\textbf{\textit{a0b}}", halign="end", size=1.5116, bold=false) => @PLACE(22, -17.4) => %label3;
//   $CANVAS_LABEL @ATTACH(bind="net") %label3(label);
//   &b0 @TEXT("\textbf{\textit{b0}}", halign="end", size=1.5116, bold=false) => @PLACE(22, -23.4) => %label4;
//   $CANVAS_LABEL @ATTACH(bind="net") %label4(label);
//   #M15
//       @TEXT("\textbf{\textit{M}}_{\textbf{15}}", key="name", dx=0.5, dy=-0.5, halign="start", valign="baseline", size=1.5116,
//       bold=false, textvisible=true);
//   $CANVAS_LABEL @ATTACH(bind="name") #M15::name(label);
//   #M16
//       @TEXT("\textbf{\textit{M}}_{\textbf{16}}", key="name", dx=0.5, dy=-0.5, halign="start", valign="baseline", size=1.5116,
//       bold=false, textvisible=true);
//   $CANVAS_LABEL @ATTACH(bind="name") #M16::name(label);
//   &a1 @TEXT("\textbf{\textit{a1}}", halign="end", size=1.5116, bold=false) => @PLACE(36, -17.4) => %label5;
//   $CANVAS_LABEL @ATTACH(bind="net") %label5(label);
//   &b1b @TEXT("\textbf{\textit{b1b}}", halign="end", size=1.5116, bold=false) => @PLACE(36, -23.4) => %label6;
//   $CANVAS_LABEL @ATTACH(bind="net") %label6(label);
//   #M17
//       @TEXT("\textbf{\textit{M}}_{\textbf{17}}", key="name", dx=0.5, dy=-0.5, halign="start", valign="baseline", size=1.5116,
//       bold=false, textvisible=true);
//   $CANVAS_LABEL @ATTACH(bind="name") #M17::name(label);
//   #M18
//       @TEXT("\textbf{\textit{M}}_{\textbf{18}}", key="name", dx=0.5, dy=-0.5, halign="start", valign="baseline", size=1.5116,
//       bold=false, textvisible=true);
//   $CANVAS_LABEL @ATTACH(bind="name") #M18::name(label);
//   &a1b @TEXT("\textbf{\textit{a1b}}", halign="end", size=1.5116, bold=false) => @PLACE(50, -17.4) => %label7;
//   $CANVAS_LABEL @ATTACH(bind="net") %label7(label);
//   &b1 @TEXT("\textbf{\textit{b1}}", halign="end", size=1.5116, bold=false) => @PLACE(50, -23.4) => %label8;
//   $CANVAS_LABEL @ATTACH(bind="net") %label8(label);
//   #CE
//       @TEXT("\textbf{\textit{C}}_{\textbf{E}}", key="name", dx=1.2, dy=-0.5, halign="start", valign="baseline", size=1.5116,
//       bold=false, textvisible=true);
//   $CANVAS_LABEL @ATTACH(bind="name") #CE::name(label);
//   #CE
//       @TEXT("\textbf{100f}", key="value", dx=1.2, dy=-2.5, halign="start", valign="baseline", size=1.5116, bold=false,
//       textvisible=true);
//   $CANVAS_LABEL @ATTACH(bind="value") #CE::value(label);
//   %port1 @TEXT("\textbf{\textit{eq}}", dx=1.4, dy=-0.4, size=1.5116, bold=false) => %label9;
//   $CANVAS_LABEL @ATTACH(bind="port") %label9(label);
//   #M19
//       @TEXT("\textbf{\textit{M}}_{\textbf{19}}", key="name", dx=0.5, dy=-0.5, halign="start", valign="baseline", size=1.5116,
//       bold=false, textvisible=true);
//   $CANVAS_LABEL @ATTACH(bind="name") #M19::name(label);
//   #M20
//       @TEXT("\textbf{\textit{M}}_{\textbf{20}}", key="name", dx=0.5, dy=-0.5, halign="start", valign="baseline", size=1.5116,
//       bold=false, textvisible=true);
//   $CANVAS_LABEL @ATTACH(bind="name") #M20::name(label);
//   &a0 @TEXT("\textbf{\textit{a0}}", halign="end", size=1.5116, bold=false) => @PLACE(74, -17.4) => %label10;
//   $CANVAS_LABEL @ATTACH(bind="net") %label10(label);
//   &b0 @TEXT("\textbf{\textit{b0}}", halign="end", size=1.5116, bold=false) => @PLACE(74, -23.4) => %label11;
//   $CANVAS_LABEL @ATTACH(bind="net") %label11(label);
//   #M21
//       @TEXT("\textbf{\textit{M}}_{\textbf{21}}", key="name", dx=0.5, dy=-0.5, halign="start", valign="baseline", size=1.5116,
//       bold=false, textvisible=true);
//   $CANVAS_LABEL @ATTACH(bind="name") #M21::name(label);
//   #M22
//       @TEXT("\textbf{\textit{M}}_{\textbf{22}}", key="name", dx=0.5, dy=-0.5, halign="start", valign="baseline", size=1.5116,
//       bold=false, textvisible=true);
//   $CANVAS_LABEL @ATTACH(bind="name") #M22::name(label);
//   &a0b @TEXT("\textbf{\textit{a0b}}", halign="end", size=1.5116, bold=false) => @PLACE(90, -17.4) => %label12;
//   $CANVAS_LABEL @ATTACH(bind="net") %label12(label);
//   &b0b @TEXT("\textbf{\textit{b0b}}", halign="end", size=1.5116, bold=false) => @PLACE(90, -23.4) => %label13;
//   $CANVAS_LABEL @ATTACH(bind="net") %label13(label);
//   #M23
//       @TEXT("\textbf{\textit{M}}_{\textbf{23}}", key="name", dx=0.5, dy=-0.5, halign="start", valign="baseline", size=1.5116,
//       bold=false, textvisible=true);
//   $CANVAS_LABEL @ATTACH(bind="name") #M23::name(label);
//   #M24
//       @TEXT("\textbf{\textit{M}}_{\textbf{24}}", key="name", dx=0.5, dy=-0.5, halign="start", valign="baseline", size=1.5116,
//       bold=false, textvisible=true);
//   $CANVAS_LABEL @ATTACH(bind="name") #M24::name(label);
//   &a1 @TEXT("\textbf{\textit{a1}}", halign="end", size=1.5116, bold=false) => @PLACE(74, -32.4) => %label14;
//   $CANVAS_LABEL @ATTACH(bind="net") %label14(label);
//   &b1 @TEXT("\textbf{\textit{b1}}", halign="end", size=1.5116, bold=false) => @PLACE(74, -38.4) => %label15;
//   $CANVAS_LABEL @ATTACH(bind="net") %label15(label);
//   #M25
//       @TEXT("\textbf{\textit{M}}_{\textbf{25}}", key="name", dx=0.5, dy=-0.5, halign="start", valign="baseline", size=1.5116,
//       bold=false, textvisible=true);
//   $CANVAS_LABEL @ATTACH(bind="name") #M25::name(label);
//   #M26
//       @TEXT("\textbf{\textit{M}}_{\textbf{26}}", key="name", dx=0.5, dy=-0.5, halign="start", valign="baseline", size=1.5116,
//       bold=false, textvisible=true);
//   $CANVAS_LABEL @ATTACH(bind="name") #M26::name(label);
//   &a1b @TEXT("\textbf{\textit{a1b}}", halign="end", size=1.5116, bold=false) => @PLACE(90, -32.4) => %label16;
//   $CANVAS_LABEL @ATTACH(bind="net") %label16(label);
//   &b1b @TEXT("\textbf{\textit{b1b}}", halign="end", size=1.5116, bold=false) => @PLACE(90, -38.4) => %label17;
//   $CANVAS_LABEL @ATTACH(bind="net") %label17(label);
//   #CN
//       @TEXT("\textbf{\textit{C}}_{\textbf{N}}", key="name", dx=1.2, dy=-0.5, halign="start", valign="baseline", size=1.5116,
//       bold=false, textvisible=true);
//   $CANVAS_LABEL @ATTACH(bind="name") #CN::name(label);
//   #CN
//       @TEXT("\textbf{100f}", key="value", dx=1.2, dy=-2.5, halign="start", valign="baseline", size=1.5116, bold=false,
//       textvisible=true);
//   $CANVAS_LABEL @ATTACH(bind="value") #CN::value(label);
//   %port2 @TEXT("\textbf{\textit{ne}}", dx=1.4, dy=-0.4, size=1.5116, bold=false) => %label18;
//   $CANVAS_LABEL @ATTACH(bind="port") %label18(label);
//   #M3
//       @TEXT("\textbf{\textit{M}}_{\textbf{3}}", key="name", dx=0.4, dy=-0.5, halign="start", valign="baseline", size=1.5116,
//       bold=false, textvisible=true);
//   $CANVAS_LABEL @ATTACH(bind="name") #M3::name(label);
//   #M4
//       @TEXT("\textbf{\textit{M}}_{\textbf{4}}", key="name", dx=0.5, dy=-0.5, halign="start", valign="baseline", size=1.5116,
//       bold=false, textvisible=true);
//   $CANVAS_LABEL @ATTACH(bind="name") #M4::name(label);
//   &vdd @TEXT("\textbf{\textit{v}}_{\textbf{dd}}", halign="middle", size=1.5116, bold=false) => @PLACE(13, -33) => %power3;
//   $CANVAS_LABEL @ATTACH(bind="net") %power3(label);
//   %port3 @TEXT("\textbf{\textit{a0}}", dx=-1.4, dy=-0.4, halign="end", size=1.5116, bold=false) => %label19;
//   $CANVAS_LABEL @ATTACH(bind="port") %label19(label);
//   &a0b @TEXT("\textbf{\textit{a0b}}", size=1.5116, bold=false) => @PLACE(16, -43.4) => %label20;
//   $CANVAS_LABEL @ATTACH(bind="net") %label20(label);
//   #M5
//       @TEXT("\textbf{\textit{M}}_{\textbf{5}}", key="name", dx=0.4, dy=-0.5, halign="start", valign="baseline", size=1.5116,
//       bold=false, textvisible=true);
//   $CANVAS_LABEL @ATTACH(bind="name") #M5::name(label);
//   #M6
//       @TEXT("\textbf{\textit{M}}_{\textbf{6}}", key="name", dx=0.5, dy=-0.5, halign="start", valign="baseline", size=1.5116,
//       bold=false, textvisible=true);
//   $CANVAS_LABEL @ATTACH(bind="name") #M6::name(label);
//   &vdd @TEXT("\textbf{\textit{v}}_{\textbf{dd}}", halign="middle", size=1.5116, bold=false) => @PLACE(30, -33) => %power4;
//   $CANVAS_LABEL @ATTACH(bind="net") %power4(label);
//   %port4 @TEXT("\textbf{\textit{a1}}", dx=-1.4, dy=-0.4, halign="end", size=1.5116, bold=false) => %label21;
//   $CANVAS_LABEL @ATTACH(bind="port") %label21(label);
//   &a1b @TEXT("\textbf{\textit{a1b}}", size=1.5116, bold=false) => @PLACE(33, -43.4) => %label22;
//   $CANVAS_LABEL @ATTACH(bind="net") %label22(label);
//   #M7
//       @TEXT("\textbf{\textit{M}}_{\textbf{7}}", key="name", dx=0.4, dy=-0.5, halign="start", valign="baseline", size=1.5116,
//       bold=false, textvisible=true);
//   $CANVAS_LABEL @ATTACH(bind="name") #M7::name(label);
//   #M8
//       @TEXT("\textbf{\textit{M}}_{\textbf{8}}", key="name", dx=0.5, dy=-0.5, halign="start", valign="baseline", size=1.5116,
//       bold=false, textvisible=true);
//   $CANVAS_LABEL @ATTACH(bind="name") #M8::name(label);
//   &vdd @TEXT("\textbf{\textit{v}}_{\textbf{dd}}", halign="middle", size=1.5116, bold=false) => @PLACE(47, -33) => %power5;
//   $CANVAS_LABEL @ATTACH(bind="net") %power5(label);
//   %port5 @TEXT("\textbf{\textit{b0}}", dx=-1.4, dy=-0.4, halign="end", size=1.5116, bold=false) => %label23;
//   $CANVAS_LABEL @ATTACH(bind="port") %label23(label);
//   &b0b @TEXT("\textbf{\textit{b0b}}", size=1.5116, bold=false) => @PLACE(50, -43.4) => %label24;
//   $CANVAS_LABEL @ATTACH(bind="net") %label24(label);
//   #M9
//       @TEXT("\textbf{\textit{M}}_{\textbf{9}}", key="name", dx=0.4, dy=-0.5, halign="start", valign="baseline", size=1.5116,
//       bold=false, textvisible=true);
//   $CANVAS_LABEL @ATTACH(bind="name") #M9::name(label);
//   #M10
//       @TEXT("\textbf{\textit{M}}_{\textbf{10}}", key="name", dx=0.5, dy=-0.5, halign="start", valign="baseline", size=1.5116,
//       bold=false, textvisible=true);
//   $CANVAS_LABEL @ATTACH(bind="name") #M10::name(label);
//   &vdd @TEXT("\textbf{\textit{v}}_{\textbf{dd}}", halign="middle", size=1.5116, bold=false) => @PLACE(64, -33) => %power6;
//   $CANVAS_LABEL @ATTACH(bind="net") %power6(label);
//   %port6 @TEXT("\textbf{\textit{b1}}", dx=-1.4, dy=-0.4, halign="end", size=1.5116, bold=false) => %label25;
//   $CANVAS_LABEL @ATTACH(bind="port") %label25(label);
//   &b1b @TEXT("\textbf{\textit{b1b}}", size=1.5116, bold=false) => @PLACE(67, -43.4) => %label26;
//   $CANVAS_LABEL @ATTACH(bind="net") %label26(label);
//   %vdd1 @TEXT("${p}", key="netname", textvisible=false);
//   %vdd2 @TEXT("${p}", key="netname", textvisible=false);
//   %port1 @TEXT("${p}", key="netname", textvisible=false);
//   %port2 @TEXT("${p}", key="netname", textvisible=false);
//   %vdd3 @TEXT("${p}", key="netname", textvisible=false);
//   %port3 @TEXT("${p}", key="netname", textvisible=false);
//   %vdd4 @TEXT("${p}", key="netname", textvisible=false);
//   %port4 @TEXT("${p}", key="netname", textvisible=false);
//   %vdd5 @TEXT("${p}", key="netname", textvisible=false);
//   %port5 @TEXT("${p}", key="netname", textvisible=false);
//   %vdd6 @TEXT("${p}", key="netname", textvisible=false);
//   %port6 @TEXT("${p}", key="netname", textvisible=false)
// }
ends astra_051_cmos_dcvsl_word_equality
