simulator lang=spectre
// @RNL(type="header") {
//   @VERSION("0.4");
//   @USE-PACKAGE(name="rnl-std-style", version="0.4");
//   @USE-PACKAGE(name="rnl-std-basic", version="0.4");
//   @USE-PACKAGE(name="rnl-std-semiconductors", version="0.4");
//   @USE-PACKAGE(name="rnl-std-no-labels", version="0.4");
//   @USE-PACKAGE(name="analog-canvas-extensions", version="0.7")
// }

subckt wilson_mirror (VDD VSS iout)
IREF (VDD net1) isource dc=20u
M1 (net1 net0 VSS VSS) sky130_fd_pr__nfet_01v8 l=0.5 w=4 nf=1 m=1
M2 (net0 net0 VSS VSS) sky130_fd_pr__nfet_01v8 l=0.5 w=4 nf=1 m=1
M3 (iout net1 net0 VSS) sky130_fd_pr__nfet_01v8 l=0.5 w=4 nf=1 m=1
// @RNL(author="analog-canvas") {
//   %wilson_mirror_SYMBOL = @DEFINE-SYMBOL(box=[-5, -4, 5, 4]) {
//     (0, 4) @PIN(terminal="VDD", label="\textbf{\textit{V}}_{\textbf{DD}}", direction="up");
//     (5, -1) @PIN(terminal="iout", label="\textbf{\textit{i}}_{\textbf{out}}", direction="right");
//     (0, 0) @RECTANGLE(width=8, height=6);
//     @LINE {(0, 4) (0, 3)};
//     @LINE {(5, -1) (4, -1)}
//   };
//   # @SET-SYMBOL %wilson_mirror_SYMBOL;
//   $CANVAS_TYPESETTING @ATTACH(subscript_italic=false) #(level);
//   #IREF @SET-SYMBOL $CURRENT_SOURCE => @PLACE(16, 11) => @ORIENT("R0");
//   $CANVAS_PARAMETER_TEXT @ATTACH(name="dc", text="20uA") #IREF(part);
//   $CANVAS_PARAMETER @ATTACH(name="amplitude", text="1m") #IREF(part);
//   $CANVAS_PARAMETER @ATTACH(name="damping", text="0") #IREF(part);
//   $CANVAS_PARAMETER @ATTACH(name="delay", text="0") #IREF(part);
//   $CANVAS_PARAMETER @ATTACH(name="fall", text="1ps") #IREF(part);
//   $CANVAS_PARAMETER @ATTACH(name="frequency", text="1k") #IREF(part);
//   $CANVAS_PARAMETER @ATTACH(name="high", text="1m") #IREF(part);
//   $CANVAS_PARAMETER @ATTACH(name="low", text="0") #IREF(part);
//   $CANVAS_PARAMETER @ATTACH(name="offset", text="0") #IREF(part);
//   $CANVAS_PARAMETER @ATTACH(name="period", text="10ns") #IREF(part);
//   $CANVAS_PARAMETER @ATTACH(name="phase", text="0") #IREF(part);
//   $CANVAS_PARAMETER @ATTACH(name="rise", text="1ps") #IREF(part);
//   $CANVAS_PARAMETER @ATTACH(name="waveform", text="dc") #IREF(part);
//   $CANVAS_PARAMETER @ATTACH(name="width", text="5ns") #IREF(part);
//   #M1 @SET-SYMBOL(terminals=[[1, "d"], [2, "g"], [3, "s"]]) $NMOS => @PLACE(16, -2) => @ORIENT("MY");
//   $CANVAS_PARAMETER_TEXT @ATTACH(name="l", text="0.5u") #M1(part);
//   #M2 @SET-SYMBOL(terminals=[[1, "d"], [2, "g"], [3, "s"]]) $NMOS => @PLACE(26, -2) => @ORIENT("R0");
//   $CANVAS_PARAMETER_TEXT @ATTACH(name="l", text="0.5u") #M2(part);
//   #M3 @SET-SYMBOL(terminals=[[1, "d"], [2, "g"], [3, "s"]]) $NMOS => @PLACE(26, 6) => @ORIENT("R0");
//   $CANVAS_PARAMETER_TEXT @ATTACH(name="l", text="0.5u") #M3(part);
//   $GROUND @ATTACH &VSS(p) => @SET-SYMBOL $GROUND_SYMBOL => @PLACE(16, -6) => @ORIENT("R0") => %gnd1;
//   $GROUND @ATTACH &VSS(p) => @SET-SYMBOL $GROUND_SYMBOL => @PLACE(26, -6) => @ORIENT("R0") => %gnd2;
//   $IO_PORT @ATTACH &iout(p) => @SET-SYMBOL $IO_PORT_SYMBOL => @PLACE(26, 10) => @ORIENT("R270") => %port1;
//   %j1 = (12, 16);
//   %j2 = (22, 16);
//   %j3 = (16, 16);
//   %j4 = (16, 6);
//   %j5 = (21, -2);
//   %j6 = (26, 2);
//   &VDD @WIRE(mode="straight", linestyle="bold") {%j1 %j3};
//   &VDD @WIRE(mode="straight", linestyle="bold") {%j3 %j2};
//   &VDD @WIRE(mode="straight") {#IREF:1 %j3};
//   &net1 @WIRE(mode="straight") {#IREF:2 %j4};
//   &net1 @WIRE(mode="straight") {%j4 #M1:1};
//   &VSS @WIRE(mode="straight") {#M1:3 %gnd1::pin};
//   &VSS @WIRE(mode="straight") {#M2:3 %gnd2::pin};
//   &net1 @WIRE(mode="straight") {%j4 #M3:2};
//   &net0 @WIRE(mode="straight") {#M3:3 %j6};
//   &net0 @WIRE(mode="straight") {%j6 #M2:1};
//   &net0 @WIRE(mode="straight") {#M1:2 %j5};
//   &net0 @WIRE(mode="straight") {%j5 #M2:2};
//   &net0 @WIRE(mode="straight") {%j5 (21, 2) %j6};
//   &iout @WIRE(mode="straight") {#M3:1 %port1::pin};
//   $JUNCTION @ATTACH %j3(p) => @PLACE(16, 16) => %dot1;
//   $JUNCTION @ATTACH %j5(p) => @PLACE(21, -2) => %dot2;
//   $JUNCTION @ATTACH %j6(p) => @PLACE(26, 2) => %dot3;
//   $JUNCTION @ATTACH %j4(p) => @PLACE(16, 6) => %dot4;
//   &VDD @TEXT("\textbf{\textit{V}}_{\textbf{DD}}", size=1.5116, bold=false) => @PLACE(23, 15) => %power1;
//   $CANVAS_LABEL @ATTACH(bind="port") %power1(label);
//   #IREF
//       @TEXT("\textbf{\textit{I}}_{\textbf{REF}}", key="name", dx=1.5, dy=-0.5, halign="start", valign="baseline", size=1.5116,
//       bold=false, textvisible=true);
//   $CANVAS_LABEL @ATTACH(bind="name") #IREF::name(label);
//   #IREF
//       @TEXT("\textbf{20uA}", key="value", dx=1.5, dy=-2.5, halign="start", valign="baseline", size=1.5116, bold=false,
//       textvisible=true);
//   $CANVAS_LABEL @ATTACH(bind="value") #IREF::value(label);
//   #M1
//       @TEXT("\textbf{\textit{M}}_{\textbf{1}}", key="name", dx=-0.5, dy=-0.5, halign="end", valign="baseline", size=1.5116,
//       bold=false, textvisible=true);
//   $CANVAS_LABEL @ATTACH(bind="name") #M1::name(label);
//   #M2
//       @TEXT("\textbf{\textit{M}}_{\textbf{2}}", key="name", dx=0.5, dy=-0.5, halign="start", valign="baseline", size=1.5116,
//       bold=false, textvisible=true);
//   $CANVAS_LABEL @ATTACH(bind="name") #M2::name(label);
//   #M3
//       @TEXT("\textbf{\textit{M}}_{\textbf{3}}", key="name", dx=0.5, dy=-0.5, halign="start", valign="baseline", size=1.5116,
//       bold=false, textvisible=true);
//   $CANVAS_LABEL @ATTACH(bind="name") #M3::name(label);
//   %port1
//       @TEXT("\textbf{\textit{i}}_{\textbf{out}}", key="netname", dx=0, dy=1.9, halign="middle", valign="baseline", size=1.5116,
//       bold=false, textvisible=true);
//   $CANVAS_LABEL @ATTACH(bind="port") %port1::netname(label)
// }
ends wilson_mirror
