simulator lang=spectre
// @RNL(type="header") {
//   @VERSION("0.4");
//   @USE-PACKAGE(name="rnl-std-style", version="0.4");
//   @USE-PACKAGE(name="rnl-std-basic", version="0.4");
//   @USE-PACKAGE(name="rnl-std-semiconductors", version="0.4");
//   @USE-PACKAGE(name="rnl-std-no-labels", version="0.4");
//   @USE-PACKAGE(name="analog-canvas-extensions", version="0.7")
// }

subckt Main (VDD VSS Vin Vout)
I1 (VDD net0) isource dc=100u
M1 (Vin net0 VSS VSS) sky130_fd_pr__nfet_01v8 l=0.15 w=1 nf=1 m=1
M2 (Vout net0 VSS VSS) sky130_fd_pr__nfet_01v8 l=0.15 w=1 nf=1 m=1
R1 (net0 Vin) resistor r=1k
R2 (Vout net0) resistor r=1k
// @RNL(author="analog-canvas") {
//   $CANVAS_TYPESETTING @ATTACH #(level);
//   #M1 @SET-SYMBOL(terminals=[[1, "d"], [2, "g"], [3, "s"]]) $NMOS => @PLACE(26, -34) => @ORIENT("MY");
//   #M2 @SET-SYMBOL(terminals=[[1, "d"], [2, "g"], [3, "s"]]) $NMOS => @PLACE(46, -34) => @ORIENT("R0");
//   #R1 @SET-SYMBOL $RESISTOR => @PLACE(31, -29) => @ORIENT("R270");
//   #R2 @SET-SYMBOL $RESISTOR => @PLACE(41, -29) => @ORIENT("R270");
//   #I1 @SET-SYMBOL $CURRENT_SOURCE => @PLACE(36, -27) => @ORIENT("R0");
//   $GROUND @ATTACH &VSS(p) => @SET-SYMBOL $GROUND_SYMBOL => @PLACE(26, -36) => @ORIENT("R0") => %gnd1;
//   $GROUND @ATTACH &VSS(p) => @SET-SYMBOL $GROUND_SYMBOL => @PLACE(46, -36) => @ORIENT("R0") => %gnd2;
//   $IO_PORT @ATTACH &Vin(p) => @SET-SYMBOL $IO_PORT_SYMBOL => @PLACE(26, -27) => @ORIENT("R270") => %port1;
//   $IO_PORT @ATTACH &Vout(p) => @SET-SYMBOL $IO_PORT_SYMBOL => @PLACE(46, -27) => @ORIENT("R270") => %port2;
//   $SUPPLY @ATTACH &VDD(p) => @SET-SYMBOL $SUPPLY_SYMBOL => @PLACE(36, -25) => @ORIENT("R0") => %vdd1;
//   %j1 = (46, -29);
//   %j2 = (46, -27);
//   %j3 = (26, -29);
//   %j4 = (26, -27);
//   %j5 = (36, -34);
//   %j6 = (37, -34);
//   %j7 = (35, -34);
//   %j8 = (36, -26);
//   &net0 @WIRE(mode="straight") {#M1:2 %j7};
//   &net0 @WIRE(mode="straight") {%j7 %j5};
//   &net0 @WIRE(mode="straight") {%j5 %j6};
//   &net0 @WIRE(mode="straight") {%j6 #M2:2};
//   &Vout @WIRE(mode="straight") {#R2:1 %j1};
//   &Vout @WIRE(mode="straight") {%j1 #M2:1};
//   &Vout @WIRE(mode="straight") {%j1 %j2};
//   &Vin @WIRE(mode="straight") {#M1:1 %j3};
//   &Vin @WIRE(mode="straight") {%j3 #R1:2};
//   &Vin @WIRE(mode="straight") {%j3 %j4};
//   &net0 @WIRE(mode="straight") {#I1:2 %j5};
//   &net0 @WIRE(mode="straight") {#R2:2 (37, -29) %j6};
//   &net0 @WIRE(mode="straight") {#R1:1 (35, -29) %j7};
//   &VDD @WIRE(mode="straight") {#I1:1 %j8};
//   &VSS @WIRE(mode="straight") {%gnd1::pin #M1:3};
//   &VSS @WIRE(mode="straight") {%gnd2::pin #M2:3};
//   &VDD @WIRE(mode="straight") {#I1:1 %vdd1::pin};
//   &Vout @WIRE(mode="straight") {%j2 %port2::pin};
//   $JUNCTION @ATTACH %j1(p) => @PLACE(46, -29) => %dot1;
//   $JUNCTION @ATTACH %j7(p) => @PLACE(35, -34) => %dot2;
//   $JUNCTION @ATTACH %j5(p) => @PLACE(36, -34) => %dot3;
//   $JUNCTION @ATTACH %j6(p) => @PLACE(37, -34) => %dot4;
//   &Vin @WIRE(mode="straight") {%j4 %port1::pin};
//   $JUNCTION @ATTACH %j3(p) => @PLACE(26, -29) => %dot5;
//   #M1
//       @TEXT("\textbf{\textit{M}}_{\textbf{11}}", key="name", dx=3, dy=2, halign="end", valign="baseline", size=1.5116,
//       bold=false, textvisible=true);
//   #M2
//       @TEXT("\textbf{\textit{M}}_{\textbf{1}}_{\textbf{2}}", key="name", dx=-3.5, dy=2, halign="start", valign="baseline",
//       size=1.5116, bold=false, textvisible=true);
//   #R1
//       @TEXT("\textbf{\textit{R}}_{\textbf{1}}", key="name", dx=-0.5, dy=1.5, halign="middle", valign="baseline", size=1.5116,
//       bold=false, textvisible=true);
//   $CANVAS_LABEL @ATTACH(bind="name") #R1::name(label);
//   #R2
//       @TEXT("\textbf{\textit{R}}_{\textbf{2}}", key="name", dx=0, dy=1.5, halign="middle", valign="baseline", size=1.5116,
//       bold=false, textvisible=true);
//   $CANVAS_LABEL @ATTACH(bind="name") #R2::name(label);
//   #I1
//       @TEXT("\textbf{\textit{I}}_{\textbf{B}}", key="name", dx=2, dy=-0.5, halign="start", valign="baseline", size=1.5116,
//       bold=false, textvisible=true);
//   %port1
//       @TEXT("\textbf{\textit{V}}_{\textbf{in}}", key="netname", dx=-0.5, dy=2, halign="start", valign="baseline", size=1.5116,
//       bold=false, textvisible=true);
//   $CANVAS_LABEL @ATTACH(bind="port") %port1::netname(label);
//   %port2
//       @TEXT("\textbf{\textit{V}}_{\textbf{out}}", key="netname", dx=-2, dy=2, halign="start", valign="baseline", size=1.5116,
//       bold=false, textvisible=true);
//   $CANVAS_LABEL @ATTACH(bind="port") %port2::netname(label);
//   %vdd1 @TEXT("\textbf{\textit{V}}_{\textbf{DD}}", dx=2, dy=1, size=1.5116, bold=false) => %power1;
//   $CANVAS_LABEL @ATTACH(bind="port") %power1(label);
//   (36, -36.2) @TEXT("\textbf{\textit{G}}", halign="middle", size=1.5116, bold=true) => %text1;
//   $CANVAS_TYPOGRAPHY @ATTACH(token="label") %text1(text);
//   %vdd1 @TEXT("${p}", key="netname", textvisible=false)
// }
ends Main
