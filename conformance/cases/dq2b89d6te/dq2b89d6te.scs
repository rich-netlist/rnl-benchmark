simulator lang=spectre
// @RNL(type="header") {
//   @VERSION("0.3");
//   @USE-PACKAGE(name="rnl-std", version="0.3");
//   @USE-PACKAGE(name="rnl-std-no-labels", version="0.3");
//   @USE-PACKAGE(name="analog-canvas-extensions", version="0.6");
//   @USE-PACKAGE(name="rnl-std-logic", version="0.3")
// }

// Ideal inverter: switches at V(VDD,VSS)/2; vt sets the step width, td the delay
subckt inverter (A Y VDD VSS)
parameters vt=10m td=10p
BhA (hA 0) bsource v=0.5*(1+tanh((v(A,VSS)-0.5*v(VDD,VSS))/vt))
Bf (nfn VSS) bsource v=v(VDD,VSS)*(1-v(hA))
Rd (nfn ndl) resistor r=1k
Cd (ndl VSS) capacitor c=td/1000
BY (Y VSS) bsource v=v(ndl,VSS)
ends inverter

subckt dut (VDD VSS RST RST1 RST2 D CLKa CLKn CLK Q)
M1 (net27 RST VDD VDD) sky130_fd_pr__pfet_01v8 l=0.15 w=1 nf=1 m=1
M10 (net24 D net0 VSS) sky130_fd_pr__nfet_01v8 l=0.15 w=1 nf=1 m=1
M11 (net0 RST1 VSS VSS) sky130_fd_pr__nfet_01v8 l=0.15 w=1 nf=1 m=1
M12 (net8 D VDD VDD) sky130_fd_pr__pfet_01v8 l=0.15 w=1 nf=1 m=1
M13 (net8 D net1 VSS) sky130_fd_pr__nfet_01v8 l=0.15 w=1 nf=1 m=1
M14 (net1 RST2 VSS VSS) sky130_fd_pr__nfet_01v8 l=0.15 w=1 nf=1 m=1
M15 (net24 CLKa net12 VDD) sky130_fd_pr__pfet_01v8 l=0.15 w=1 nf=1 m=1
M16 (net24 CLKn net12 VSS) sky130_fd_pr__nfet_01v8 l=0.15 w=1 nf=1 m=1
M17 (net12 RST1 VDD VDD) sky130_fd_pr__pfet_01v8 l=0.15 w=1 nf=1 m=1
M18 (net10 net12 VDD VDD) sky130_fd_pr__pfet_01v8 l=0.15 w=1 nf=1 m=1
M19 (net13 RST2 VDD VDD) sky130_fd_pr__pfet_01v8 l=0.15 w=1 nf=1 m=1
M2 (net22 net29 net27 VDD) sky130_fd_pr__pfet_01v8 l=0.15 w=1 nf=1 m=1
M20 (net6 net13 VDD VDD) sky130_fd_pr__pfet_01v8 l=0.15 w=1 nf=1 m=1
M21 (net8 CLKa net13 VDD) sky130_fd_pr__pfet_01v8 l=0.15 w=1 nf=1 m=1
M22 (net8 CLKn net13 VSS) sky130_fd_pr__nfet_01v8 l=0.15 w=1 nf=1 m=1
M23 (net10 net13 VSS VSS) sky130_fd_pr__nfet_01v8 l=0.15 w=1 nf=1 m=1
M24 (net6 net12 VSS VSS) sky130_fd_pr__nfet_01v8 l=0.15 w=1 nf=1 m=1
M25 (net30 net10 VDD VDD) sky130_fd_pr__pfet_01v8 l=0.15 w=1 nf=1 m=1
M26 (net12 CLKn net30 VDD) sky130_fd_pr__pfet_01v8 l=0.15 w=1 nf=1 m=1
M27 (net12 CLKa net2 VSS) sky130_fd_pr__nfet_01v8 l=0.15 w=1 nf=1 m=1
M28 (net2 net10 net16 VSS) sky130_fd_pr__nfet_01v8 l=0.15 w=1 nf=1 m=1
M29 (net16 RST2 VSS VSS) sky130_fd_pr__nfet_01v8 l=0.15 w=1 nf=1 m=1
M3 (net22 net29 net20 VSS) sky130_fd_pr__nfet_01v8 l=0.15 w=1 nf=1 m=1
M30 (net31 net6 VDD VDD) sky130_fd_pr__pfet_01v8 l=0.15 w=1 nf=1 m=1
M31 (net13 CLKn net31 VDD) sky130_fd_pr__pfet_01v8 l=0.15 w=1 nf=1 m=1
M32 (net13 CLKa net3 VSS) sky130_fd_pr__nfet_01v8 l=0.15 w=1 nf=1 m=1
M33 (net3 net6 net17 VSS) sky130_fd_pr__nfet_01v8 l=0.15 w=1 nf=1 m=1
M34 (net17 RST1 VSS VSS) sky130_fd_pr__nfet_01v8 l=0.15 w=1 nf=1 m=1
M35 (net25 net10 VDD VDD) sky130_fd_pr__pfet_01v8 l=0.15 w=1 nf=1 m=1
M36 (net25 net6 VSS VSS) sky130_fd_pr__nfet_01v8 l=0.15 w=1 nf=1 m=1
M37 (net26 net6 VDD VDD) sky130_fd_pr__pfet_01v8 l=0.15 w=1 nf=1 m=1
M38 (net26 net10 VSS VSS) sky130_fd_pr__nfet_01v8 l=0.15 w=1 nf=1 m=1
M39 (net25 CLKn net14 VDD) sky130_fd_pr__pfet_01v8 l=0.15 w=1 nf=1 m=1
M4 (net20 RST VSS VSS) sky130_fd_pr__nfet_01v8 l=0.15 w=1 nf=1 m=1
M40 (net25 CLK net14 VSS) sky130_fd_pr__nfet_01v8 l=0.15 w=1 nf=1 m=1
M41 (net26 CLKn net9 VDD) sky130_fd_pr__pfet_01v8 l=0.15 w=1 nf=1 m=1
M42 (net26 CLK net9 VSS) sky130_fd_pr__nfet_01v8 l=0.15 w=1 nf=1 m=1
M43 (net11 net14 VDD VDD) sky130_fd_pr__pfet_01v8 l=0.15 w=1 nf=1 m=1
M44 (net7 net9 VDD VDD) sky130_fd_pr__pfet_01v8 l=0.15 w=1 nf=1 m=1
M45 (net11 net9 VSS VSS) sky130_fd_pr__nfet_01v8 l=0.15 w=1 nf=1 m=1
M46 (net7 net14 VSS VSS) sky130_fd_pr__nfet_01v8 l=0.15 w=1 nf=1 m=1
M47 (net32 net11 VDD VDD) sky130_fd_pr__pfet_01v8 l=0.15 w=1 nf=1 m=1
M48 (net14 CLK net32 VDD) sky130_fd_pr__pfet_01v8 l=0.15 w=1 nf=1 m=1
M49 (net14 CLKn net4 VSS) sky130_fd_pr__nfet_01v8 l=0.15 w=1 nf=1 m=1
M5 (net28 RST VDD VDD) sky130_fd_pr__pfet_01v8 l=0.15 w=1 nf=1 m=1
M50 (net4 net11 net18 VSS) sky130_fd_pr__nfet_01v8 l=0.15 w=1 nf=1 m=1
M51 (net18 RST2 VSS VSS) sky130_fd_pr__nfet_01v8 l=0.15 w=1 nf=1 m=1
M52 (net33 net7 VDD VDD) sky130_fd_pr__pfet_01v8 l=0.15 w=1 nf=1 m=1
M53 (net9 CLK net33 VDD) sky130_fd_pr__pfet_01v8 l=0.15 w=1 nf=1 m=1
M54 (net9 CLKn net5 VSS) sky130_fd_pr__nfet_01v8 l=0.15 w=1 nf=1 m=1
M55 (net5 net7 net19 VSS) sky130_fd_pr__nfet_01v8 l=0.15 w=1 nf=1 m=1
M56 (net19 RST1 VSS VSS) sky130_fd_pr__nfet_01v8 l=0.15 w=1 nf=1 m=1
M57 (net32 RST1 VDD VDD) sky130_fd_pr__pfet_01v8 l=0.15 w=1 nf=1 m=1
M58 (net33 RST1 VDD VDD) sky130_fd_pr__pfet_01v8 l=0.15 w=1 nf=1 m=1
M59 (Q net14 VDD VDD) sky130_fd_pr__pfet_01v8 l=0.15 w=1 nf=1 m=1
M6 (net23 net29 net28 VDD) sky130_fd_pr__pfet_01v8 l=0.15 w=1 nf=1 m=1
M60 (Q net9 VSS VSS) sky130_fd_pr__nfet_01v8 l=0.15 w=1 nf=1 m=1
M7 (net23 net29 net21 VSS) sky130_fd_pr__nfet_01v8 l=0.15 w=1 nf=1 m=1
M8 (net21 RST VSS VSS) sky130_fd_pr__nfet_01v8 l=0.15 w=1 nf=1 m=1
M9 (net24 D VDD VDD) sky130_fd_pr__pfet_01v8 l=0.15 w=1 nf=1 m=1
X1 (RST net15 VDD VSS) inverter td=10p vt=10m
X2 (net15 net29 VDD VSS) inverter td=10p vt=10m
X3 (net22 RST1 VDD VSS) inverter td=10p vt=10m
X4 (net23 RST2 VDD VSS) inverter td=10p vt=10m
X5 (CLK CLKn VDD VSS) inverter td=10p vt=10m
X6 (CLKn CLKa VDD VSS) inverter td=10p vt=10m
// @RNL(author="analog-canvas") {
//   %dut_SYMBOL = @DEFINE-SYMBOL(box=[-6, -9, 6, 9]) {
//     (0, 9) @PIN(terminal="VDD", label="\textbf{\textit{V}}_{\textbf{DD}}", direction="up");
//     (-6, -2) @PIN(terminal="RST", label="\textbf{\textit{RST}}", direction="left");
//     (-6, 2) @PIN(terminal="RST1", label="\textbf{\textit{RST1}}", direction="left");
//     (-6, -6) @PIN(terminal="RST2", label="\textbf{\textit{RST2}}", direction="left");
//     (-6, -4) @PIN(terminal="D", label="\textbf{\textit{D}}", direction="left");
//     (-6, 4) @PIN(terminal="CLKa", label="\textbf{\textit{CLKa}}", direction="left");
//     (-6, 0) @PIN(terminal="CLKn", label="\textbf{\textit{CLKn}}", direction="left");
//     (6, 0) @PIN(terminal="CLK", label="\textbf{\textit{CLK}}", direction="right");
//     (6, -2) @PIN(terminal="Q", label="\textbf{\textit{Q}}", direction="right");
//     (0, 0) @RECTANGLE(width=10, height=16);
//     @LINE {(0, 9) (0, 8)};
//     @LINE {(-6, -2) (-5, -2)};
//     @LINE {(-6, 2) (-5, 2)};
//     @LINE {(-6, -6) (-5, -6)};
//     @LINE {(-6, -4) (-5, -4)};
//     @LINE {(-6, 4) (-5, 4)};
//     @LINE {(-6, 0) (-5, 0)};
//     @LINE {(6, 0) (5, 0)};
//     @LINE {(6, -2) (5, -2)}
//   };
//   # @SET-SYMBOL %dut_SYMBOL;
//   $CANVAS_TYPESETTING @ATTACH(subscript_italic=false) #(level);
//   #M1 @SET-SYMBOL $PMOS => @PLACE(47, -15) => @ORIENT("R0");
//   #M2 @SET-SYMBOL $PMOS => @PLACE(47, -19) => @ORIENT("R0");
//   #M3 @SET-SYMBOL $NMOS => @PLACE(47, -23) => @ORIENT("R0");
//   #M4 @SET-SYMBOL $NMOS => @PLACE(47, -27) => @ORIENT("R0");
//   $SUPPLY @ATTACH &VDD(p) => @SET-SYMBOL $SUPPLY_SYMBOL => @PLACE(47, -14) => @ORIENT("R0") => %vdd1;
//   $GROUND @ATTACH &VSS(p) => @SET-SYMBOL $GROUND_SYMBOL => @PLACE(47, -29) => @ORIENT("R0") => %gnd1;
//   #M5 @SET-SYMBOL $PMOS => @PLACE(47, -38) => @ORIENT("R0");
//   #M6 @SET-SYMBOL $PMOS => @PLACE(47, -42) => @ORIENT("R0");
//   #M7 @SET-SYMBOL $NMOS => @PLACE(47, -46) => @ORIENT("R0");
//   #M8 @SET-SYMBOL $NMOS => @PLACE(47, -50) => @ORIENT("R0");
//   $SUPPLY @ATTACH &VDD(p) => @SET-SYMBOL $SUPPLY_SYMBOL => @PLACE(47, -37) => @ORIENT("R0") => %vdd2;
//   $GROUND @ATTACH &VSS(p) => @SET-SYMBOL $GROUND_SYMBOL => @PLACE(47, -52) => @ORIENT("R0") => %gnd2;
//   #X1 @SET-SYMBOL $INVERTER => @PLACE(30, -44) => @ORIENT("R0");
//   #X2 @SET-SYMBOL $INVERTER => @PLACE(35, -44) => @ORIENT("R0");
//   $IO_PORT @ATTACH &RST(p) => @SET-SYMBOL $IO_PORT_SYMBOL => @PLACE(24, -34) => @ORIENT("R0") => %port1;
//   #X3 @SET-SYMBOL $INVERTER => @PLACE(52, -21) => @ORIENT("R0");
//   $IO_PORT @ATTACH &RST1(p) => @SET-SYMBOL $IO_PORT_SYMBOL => @PLACE(54, -21) => @ORIENT("MY") => %port2;
//   #M9 @SET-SYMBOL $PMOS => @PLACE(66, -14) => @ORIENT("R0");
//   #M10 @SET-SYMBOL $NMOS => @PLACE(66, -20) => @ORIENT("R0");
//   #M11 @SET-SYMBOL $NMOS => @PLACE(66, -24) => @ORIENT("R0");
//   $SUPPLY @ATTACH &VDD(p) => @SET-SYMBOL $SUPPLY_SYMBOL => @PLACE(66, -13) => @ORIENT("R0") => %vdd3;
//   $IO_PORT @ATTACH &RST1(p) => @SET-SYMBOL $IO_PORT_SYMBOL => @PLACE(63, -24) => @ORIENT("R0") => %port3;
//   #M12 @SET-SYMBOL $PMOS => @PLACE(66, -43) => @ORIENT("R0");
//   #M13 @SET-SYMBOL $NMOS => @PLACE(66, -49) => @ORIENT("R0");
//   #M14 @SET-SYMBOL $NMOS => @PLACE(66, -53) => @ORIENT("R0");
//   $SUPPLY @ATTACH &VDD(p) => @SET-SYMBOL $SUPPLY_SYMBOL => @PLACE(66, -42) => @ORIENT("R0") => %vdd4;
//   $IO_PORT @ATTACH &RST2(p) => @SET-SYMBOL $IO_PORT_SYMBOL => @PLACE(63, -53) => @ORIENT("R0") => %port4;
//   #X4 @SET-SYMBOL $INVERTER => @PLACE(52, -44) => @ORIENT("R0");
//   $IO_PORT @ATTACH &RST2(p) => @SET-SYMBOL $IO_PORT_SYMBOL => @PLACE(54, -44) => @ORIENT("MY") => %port5;
//   $GROUND @ATTACH &VSS(p) => @SET-SYMBOL $GROUND_SYMBOL => @PLACE(66, -26) => @ORIENT("R0") => %gnd3;
//   $GROUND @ATTACH &VSS(p) => @SET-SYMBOL $GROUND_SYMBOL => @PLACE(66, -55) => @ORIENT("R0") => %gnd4;
//   $IO_PORT @ATTACH &D(p) => @SET-SYMBOL $IO_PORT_SYMBOL => @PLACE(58, -36) => @ORIENT("R0") => %port6;
//   #M15 @SET-SYMBOL $PMOS => @PLACE(74, -16) => @ORIENT("R270");
//   #M16 @SET-SYMBOL $NMOS => @PLACE(74, -18) => @ORIENT("R90");
//   $IO_PORT @ATTACH &CLKa(p) => @SET-SYMBOL $IO_PORT_SYMBOL => @PLACE(74, -13) => @ORIENT("MYR90") => %port7;
//   $IO_PORT @ATTACH &CLKn(p) => @SET-SYMBOL $IO_PORT_SYMBOL => @PLACE(74, -21) => @ORIENT("MXR90") => %port8;
//   #M17 @SET-SYMBOL $PMOS => @PLACE(83, -15) => @ORIENT("R0");
//   $IO_PORT @ATTACH &RST1(p) => @SET-SYMBOL $IO_PORT_SYMBOL => @PLACE(80, -15) => @ORIENT("R0") => %port9;
//   $SUPPLY @ATTACH &VDD(p) => @SET-SYMBOL $SUPPLY_SYMBOL => @PLACE(83, -14) => @ORIENT("R0") => %vdd5;
//   #M18 @SET-SYMBOL $PMOS => @PLACE(93, -14) => @ORIENT("R0");
//   $SUPPLY @ATTACH &VDD(p) => @SET-SYMBOL $SUPPLY_SYMBOL => @PLACE(93, -13) => @ORIENT("R0") => %vdd6;
//   #M19 @SET-SYMBOL $PMOS => @PLACE(83, -44) => @ORIENT("R0");
//   $IO_PORT @ATTACH &RST2(p) => @SET-SYMBOL $IO_PORT_SYMBOL => @PLACE(80, -44) => @ORIENT("R0") => %port10;
//   $SUPPLY @ATTACH &VDD(p) => @SET-SYMBOL $SUPPLY_SYMBOL => @PLACE(83, -43) => @ORIENT("R0") => %vdd7;
//   #M20 @SET-SYMBOL $PMOS => @PLACE(93, -43) => @ORIENT("R0");
//   $SUPPLY @ATTACH &VDD(p) => @SET-SYMBOL $SUPPLY_SYMBOL => @PLACE(93, -42) => @ORIENT("R0") => %vdd8;
//   #M21 @SET-SYMBOL $PMOS => @PLACE(74, -45) => @ORIENT("R270");
//   #M22 @SET-SYMBOL $NMOS => @PLACE(74, -47) => @ORIENT("R90");
//   $IO_PORT @ATTACH &CLKa(p) => @SET-SYMBOL $IO_PORT_SYMBOL => @PLACE(74, -42) => @ORIENT("MYR90") => %port11;
//   $IO_PORT @ATTACH &CLKn(p) => @SET-SYMBOL $IO_PORT_SYMBOL => @PLACE(74, -50) => @ORIENT("MXR90") => %port12;
//   #M23 @SET-SYMBOL $NMOS => @PLACE(93, -20) => @ORIENT("R0");
//   #M24 @SET-SYMBOL $NMOS => @PLACE(93, -49) => @ORIENT("R0");
//   $GROUND @ATTACH &VSS(p) => @SET-SYMBOL $GROUND_SYMBOL => @PLACE(93, -21) => @ORIENT("R0") => %gnd5;
//   $GROUND @ATTACH &VSS(p) => @SET-SYMBOL $GROUND_SYMBOL => @PLACE(93, -50) => @ORIENT("R0") => %gnd6;
//   #M25 @SET-SYMBOL $PMOS => @PLACE(100, -9) => @ORIENT("MY");
//   #M26 @SET-SYMBOL $PMOS => @PLACE(100, -13) => @ORIENT("MY");
//   #M27 @SET-SYMBOL $NMOS => @PLACE(100, -21) => @ORIENT("MY");
//   #M28 @SET-SYMBOL $NMOS => @PLACE(100, -25) => @ORIENT("MY");
//   $SUPPLY @ATTACH &VDD(p) => @SET-SYMBOL $SUPPLY_SYMBOL => @PLACE(100, -8) => @ORIENT("R0") => %vdd9;
//   $IO_PORT @ATTACH &CLKn(p) => @SET-SYMBOL $IO_PORT_SYMBOL => @PLACE(103, -13) => @ORIENT("MY") => %port13;
//   $IO_PORT @ATTACH &CLKa(p) => @SET-SYMBOL $IO_PORT_SYMBOL => @PLACE(103, -21) => @ORIENT("MY") => %port14;
//   #M29 @SET-SYMBOL $NMOS => @PLACE(100, -29) => @ORIENT("MY");
//   $IO_PORT @ATTACH &RST2(p) => @SET-SYMBOL $IO_PORT_SYMBOL => @PLACE(103, -29) => @ORIENT("MY") => %port15;
//   $GROUND @ATTACH &VSS(p) => @SET-SYMBOL $GROUND_SYMBOL => @PLACE(100, -30) => @ORIENT("R0") => %gnd7;
//   #M30 @SET-SYMBOL $PMOS => @PLACE(100, -40) => @ORIENT("MY");
//   #M31 @SET-SYMBOL $PMOS => @PLACE(100, -44) => @ORIENT("MY");
//   #M32 @SET-SYMBOL $NMOS => @PLACE(100, -52) => @ORIENT("MY");
//   #M33 @SET-SYMBOL $NMOS => @PLACE(100, -56) => @ORIENT("MY");
//   $SUPPLY @ATTACH &VDD(p) => @SET-SYMBOL $SUPPLY_SYMBOL => @PLACE(100, -39) => @ORIENT("R0") => %vdd10;
//   $IO_PORT @ATTACH &CLKn(p) => @SET-SYMBOL $IO_PORT_SYMBOL => @PLACE(103, -44) => @ORIENT("MY") => %port16;
//   $IO_PORT @ATTACH &CLKa(p) => @SET-SYMBOL $IO_PORT_SYMBOL => @PLACE(103, -52) => @ORIENT("MY") => %port17;
//   #M34 @SET-SYMBOL $NMOS => @PLACE(100, -60) => @ORIENT("MY");
//   $IO_PORT @ATTACH &RST1(p) => @SET-SYMBOL $IO_PORT_SYMBOL => @PLACE(103, -60) => @ORIENT("MY") => %port18;
//   $GROUND @ATTACH &VSS(p) => @SET-SYMBOL $GROUND_SYMBOL => @PLACE(100, -61) => @ORIENT("R0") => %gnd8;
//   #M35 @SET-SYMBOL $PMOS => @PLACE(117, -13) => @ORIENT("R0");
//   $GROUND @ATTACH &VSS(p) => @SET-SYMBOL $GROUND_SYMBOL => @PLACE(117, -19) => @ORIENT("R0") => %gnd9;
//   #M37 @SET-SYMBOL $PMOS => @PLACE(117, -44) => @ORIENT("R0");
//   $GROUND @ATTACH &VSS(p) => @SET-SYMBOL $GROUND_SYMBOL => @PLACE(117, -50) => @ORIENT("R0") => %gnd10;
//   $SUPPLY @ATTACH &VDD(p) => @SET-SYMBOL $SUPPLY_SYMBOL => @PLACE(117, -11) => @ORIENT("R0") => %vdd11;
//   $SUPPLY @ATTACH &VDD(p) => @SET-SYMBOL $SUPPLY_SYMBOL => @PLACE(117, -42) => @ORIENT("R0") => %vdd12;
//   #M39 @SET-SYMBOL $PMOS => @PLACE(128, -14) => @ORIENT("R270");
//   #M40 @SET-SYMBOL $NMOS => @PLACE(128, -16) => @ORIENT("R90");
//   $IO_PORT @ATTACH &CLKn(p) => @SET-SYMBOL $IO_PORT_SYMBOL => @PLACE(128, -11) => @ORIENT("MYR90") => %port19;
//   $IO_PORT @ATTACH &CLK(p) => @SET-SYMBOL $IO_PORT_SYMBOL => @PLACE(128, -19) => @ORIENT("MXR90") => %port20;
//   #M41 @SET-SYMBOL $PMOS => @PLACE(127, -45) => @ORIENT("R270");
//   #M42 @SET-SYMBOL $NMOS => @PLACE(127, -47) => @ORIENT("R90");
//   $IO_PORT @ATTACH &CLKn(p) => @SET-SYMBOL $IO_PORT_SYMBOL => @PLACE(127, -42) => @ORIENT("MYR90") => %port21;
//   $IO_PORT @ATTACH &CLK(p) => @SET-SYMBOL $IO_PORT_SYMBOL => @PLACE(127, -50) => @ORIENT("MXR90") => %port22;
//   #M43 @SET-SYMBOL $PMOS => @PLACE(143, -12) => @ORIENT("R0");
//   $SUPPLY @ATTACH &VDD(p) => @SET-SYMBOL $SUPPLY_SYMBOL => @PLACE(143, -11) => @ORIENT("R0") => %vdd13;
//   #M44 @SET-SYMBOL $PMOS => @PLACE(143, -43) => @ORIENT("R0");
//   $SUPPLY @ATTACH &VDD(p) => @SET-SYMBOL $SUPPLY_SYMBOL => @PLACE(143, -42) => @ORIENT("R0") => %vdd14;
//   #M45 @SET-SYMBOL $NMOS => @PLACE(143, -18) => @ORIENT("R0");
//   #M46 @SET-SYMBOL $NMOS => @PLACE(143, -49) => @ORIENT("R0");
//   $GROUND @ATTACH &VSS(p) => @SET-SYMBOL $GROUND_SYMBOL => @PLACE(143, -19) => @ORIENT("R0") => %gnd11;
//   $GROUND @ATTACH &VSS(p) => @SET-SYMBOL $GROUND_SYMBOL => @PLACE(143, -50) => @ORIENT("R0") => %gnd12;
//   #M47 @SET-SYMBOL $PMOS => @PLACE(150, -7) => @ORIENT("MY");
//   #M48 @SET-SYMBOL $PMOS => @PLACE(150, -11) => @ORIENT("MY");
//   #M49 @SET-SYMBOL $NMOS => @PLACE(150, -19) => @ORIENT("MY");
//   #M50 @SET-SYMBOL $NMOS => @PLACE(150, -23) => @ORIENT("MY");
//   $SUPPLY @ATTACH &VDD(p) => @SET-SYMBOL $SUPPLY_SYMBOL => @PLACE(150, -6) => @ORIENT("R0") => %vdd15;
//   $IO_PORT @ATTACH &CLK(p) => @SET-SYMBOL $IO_PORT_SYMBOL => @PLACE(153, -11) => @ORIENT("MY") => %port23;
//   $IO_PORT @ATTACH &CLKn(p) => @SET-SYMBOL $IO_PORT_SYMBOL => @PLACE(153, -19) => @ORIENT("MY") => %port24;
//   #M51 @SET-SYMBOL $NMOS => @PLACE(150, -27) => @ORIENT("MY");
//   $IO_PORT @ATTACH &RST2(p) => @SET-SYMBOL $IO_PORT_SYMBOL => @PLACE(153, -27) => @ORIENT("MY") => %port25;
//   $GROUND @ATTACH &VSS(p) => @SET-SYMBOL $GROUND_SYMBOL => @PLACE(150, -28) => @ORIENT("R0") => %gnd13;
//   #M52 @SET-SYMBOL $PMOS => @PLACE(150, -40) => @ORIENT("MY");
//   #M53 @SET-SYMBOL $PMOS => @PLACE(150, -44) => @ORIENT("MY");
//   #M54 @SET-SYMBOL $NMOS => @PLACE(150, -52) => @ORIENT("MY");
//   #M55 @SET-SYMBOL $NMOS => @PLACE(150, -56) => @ORIENT("MY");
//   $SUPPLY @ATTACH &VDD(p) => @SET-SYMBOL $SUPPLY_SYMBOL => @PLACE(150, -39) => @ORIENT("R0") => %vdd16;
//   $IO_PORT @ATTACH &CLK(p) => @SET-SYMBOL $IO_PORT_SYMBOL => @PLACE(153, -44) => @ORIENT("MY") => %port26;
//   $IO_PORT @ATTACH &CLKn(p) => @SET-SYMBOL $IO_PORT_SYMBOL => @PLACE(153, -52) => @ORIENT("MY") => %port27;
//   #M56 @SET-SYMBOL $NMOS => @PLACE(150, -60) => @ORIENT("MY");
//   $IO_PORT @ATTACH &RST1(p) => @SET-SYMBOL $IO_PORT_SYMBOL => @PLACE(153, -60) => @ORIENT("MY") => %port28;
//   $GROUND @ATTACH &VSS(p) => @SET-SYMBOL $GROUND_SYMBOL => @PLACE(150, -61) => @ORIENT("R0") => %gnd14;
//   #M57 @SET-SYMBOL $PMOS => @PLACE(165, -7) => @ORIENT("MY");
//   $SUPPLY @ATTACH &VDD(p) => @SET-SYMBOL $SUPPLY_SYMBOL => @PLACE(165, -6) => @ORIENT("R0") => %vdd17;
//   $IO_PORT @ATTACH &RST1(p) => @SET-SYMBOL $IO_PORT_SYMBOL => @PLACE(168, -7) => @ORIENT("MY") => %port29;
//   #M58 @SET-SYMBOL $PMOS => @PLACE(164, -40) => @ORIENT("MY");
//   $SUPPLY @ATTACH &VDD(p) => @SET-SYMBOL $SUPPLY_SYMBOL => @PLACE(164, -39) => @ORIENT("R0") => %vdd18;
//   $IO_PORT @ATTACH &RST1(p) => @SET-SYMBOL $IO_PORT_SYMBOL => @PLACE(167, -40) => @ORIENT("MY") => %port30;
//   #M59 @SET-SYMBOL $PMOS => @PLACE(178, -23) => @ORIENT("R0");
//   #M60 @SET-SYMBOL $NMOS => @PLACE(178, -34) => @ORIENT("R0");
//   $SUPPLY @ATTACH &VDD(p) => @SET-SYMBOL $SUPPLY_SYMBOL => @PLACE(178, -22) => @ORIENT("R0") => %vdd19;
//   $GROUND @ATTACH &VSS(p) => @SET-SYMBOL $GROUND_SYMBOL => @PLACE(178, -36) => @ORIENT("R0") => %gnd15;
//   $IO_PORT @ATTACH &Q(p) => @SET-SYMBOL $IO_PORT_SYMBOL => @PLACE(179, -29) => @ORIENT("MY") => %port31;
//   #M36 @SET-SYMBOL $NMOS => @PLACE(117, -17) => @ORIENT("R0");
//   #M38 @SET-SYMBOL $NMOS => @PLACE(117, -48) => @ORIENT("R0");
//   #X5 @SET-SYMBOL $INVERTER => @PLACE(80, -6) => @ORIENT("R0");
//   #X6 @SET-SYMBOL $INVERTER => @PLACE(87, -6) => @ORIENT("R0");
//   $IO_PORT @ATTACH &CLK(p) => @SET-SYMBOL $IO_PORT_SYMBOL => @PLACE(77, -6) => @ORIENT("R0") => %port32;
//   $IO_PORT @ATTACH &CLKa(p) => @SET-SYMBOL $IO_PORT_SYMBOL => @PLACE(89, -6) => @ORIENT("MY") => %port33;
//   &VDD @REMOVE-FROM $PORT_FILL_SET;
//   &VSS @REMOVE-FROM $PORT_FILL_SET;
//   %j1 = (41, -23);
//   $JUNCTION @ATTACH %j1;
//   %j2 = (41, -42);
//   $JUNCTION @ATTACH %j2;
//   %j3 = (38, -23);
//   $JUNCTION @ATTACH %j3;
//   %j4 = (41, -44);
//   $JUNCTION @ATTACH %j4;
//   %j5 = (26, -34);
//   $JUNCTION @ATTACH %j5;
//   %j6 = (38, -27);
//   $JUNCTION @ATTACH %j6;
//   %j7 = (38, -38);
//   $JUNCTION @ATTACH %j7;
//   %j8 = (59, -20);
//   $JUNCTION @ATTACH %j8;
//   %j9 = (59, -43);
//   $JUNCTION @ATTACH %j9;
//   %j10 = (59, -36);
//   $JUNCTION @ATTACH %j10;
//   %j11 = (66, -17);
//   $JUNCTION @ATTACH %j11;
//   %j12 = (72, -17);
//   $JUNCTION @ATTACH %j12;
//   %j13 = (76, -17);
//   $JUNCTION @ATTACH %j13;
//   %j14 = (72, -46);
//   $JUNCTION @ATTACH %j14;
//   %j15 = (76, -46);
//   $JUNCTION @ATTACH %j15;
//   %j16 = (66, -46);
//   $JUNCTION @ATTACH %j16;
//   %j17 = (88, -43);
//   $JUNCTION @ATTACH %j17;
//   %j18 = (86, -17);
//   $JUNCTION @ATTACH %j18;
//   %j19 = (86, -17);
//   %j20 = (100, -17);
//   $JUNCTION @ATTACH %j20;
//   %j21 = (109, -18);
//   $JUNCTION @ATTACH %j21;
//   %j22 = (109, -47);
//   $JUNCTION @ATTACH %j22;
//   %j23 = (88, -46);
//   $JUNCTION @ATTACH %j23;
//   %j24 = (109, -25);
//   $JUNCTION @ATTACH %j24;
//   %j25 = (109, -40);
//   $JUNCTION @ATTACH %j25;
//   %j26 = (126, -15);
//   $JUNCTION @ATTACH %j26;
//   %j27 = (130, -15);
//   $JUNCTION @ATTACH %j27;
//   %j28 = (125, -46);
//   $JUNCTION @ATTACH %j28;
//   %j29 = (136, -15);
//   $JUNCTION @ATTACH %j29;
//   %j30 = (136, -15);
//   %j31 = (150, -15);
//   $JUNCTION @ATTACH %j31;
//   %j32 = (159, -16);
//   $JUNCTION @ATTACH %j32;
//   %j33 = (159, -47);
//   $JUNCTION @ATTACH %j33;
//   %j34 = (178, -29);
//   $JUNCTION @ATTACH %j34;
//   %j35 = (113, -40);
//   $JUNCTION @ATTACH %j35;
//   %j36 = (129, -46);
//   $JUNCTION @ATTACH %j36;
//   %j37 = (138, -43);
//   $JUNCTION @ATTACH %j37;
//   %j38 = (138, -46);
//   $JUNCTION @ATTACH %j38;
//   %j39 = (111, -24);
//   %j40 = (111, -25);
//   $JUNCTION @ATTACH %j40;
//   &VDD @WIRE(mode="straight") {#M1:3 %vdd1:p};
//   &VDD @WIRE(mode="straight") {#M5:3 %vdd2:p};
//   &net29 @WIRE(mode="straight") {#M2:2 (41, -19) %j1};
//   &net29 @WIRE(mode="straight") {%j1 #M3:2};
//   &net29 @WIRE(mode="straight") {%j1 %j2};
//   &net29 @WIRE(mode="straight") {%j2 #M6:2};
//   &net29 @WIRE(mode="straight") {%j2 %j4};
//   &net29 @WIRE(mode="straight") {%j4 (41, -46) #M7:2};
//   &net29 @WIRE(mode="straight") {#X2:2 %j4};
//   &RST @WIRE(mode="straight") {%port1:p %j5};
//   &RST @WIRE(mode="straight") {%j5 (26, -44) #X1:1};
//   &RST @WIRE(mode="straight") {%j5 (26, -23) %j3};
//   &RST @WIRE(mode="straight") {%j3 %j6};
//   &RST @WIRE(mode="straight") {%j3 (38, -15) #M1:2};
//   &RST @WIRE(mode="straight") {%j6 %j7};
//   &RST @WIRE(mode="straight") {%j6 #M4:2};
//   &RST @WIRE(mode="straight") {%j7 #M5:2};
//   &RST @WIRE(mode="straight") {%j7 (38, -50) #M8:2};
//   &net22 @WIRE(mode="straight") {#X3:1 #M2:1};
//   &net24 @WIRE(mode="straight") {#M9:1 %j11};
//   &net24 @WIRE(mode="straight") {%j11 #M10:1};
//   &VDD @WIRE(mode="straight") {#M9:3 %vdd3:p};
//   &VDD @WIRE(mode="straight") {#M12:3 %vdd4:p};
//   &net23 @WIRE(mode="straight") {#X4:1 #M6:1};
//   &D @WIRE(mode="straight") {%j8 %j10};
//   &D @WIRE(mode="straight") {%j10 %j9};
//   &D @WIRE(mode="straight") {%j8 (59, -14) #M9:2};
//   &D @WIRE(mode="straight") {%j8 #M10:2};
//   &D @WIRE(mode="straight") {%j9 #M12:2};
//   &D @WIRE(mode="straight") {%j9 (59, -49) #M13:2};
//   &D @WIRE(mode="straight") {%port6:p %j10};
//   &net24 @WIRE(mode="straight") {%j11 %j12};
//   &net24 @WIRE(mode="straight") {#M15:1 %j12};
//   &net24 @WIRE(mode="straight") {%j12 #M16:1};
//   &VDD @WIRE(mode="straight") {#M17:3 %vdd5:p};
//   &VDD @WIRE(mode="straight") {#M18:3 %vdd6:p};
//   &VDD @WIRE(mode="straight") {#M19:3 %vdd7:p};
//   &VDD @WIRE(mode="straight") {#M20:3 %vdd8:p};
//   &net8 @WIRE(mode="straight") {#M12:1 %j16};
//   &net8 @WIRE(mode="straight") {%j16 #M13:1};
//   &net8 @WIRE(mode="straight") {#M21:1 %j14};
//   &net8 @WIRE(mode="straight") {%j14 #M22:1};
//   &net8 @WIRE(mode="straight") {%j14 %j16};
//   &VSS @WIRE(mode="straight") {%gnd5:p #M23:3};
//   &VSS @WIRE(mode="straight") {%gnd6:p #M24:3};
//   &VDD @WIRE(mode="straight") {#M25:3 %vdd9:p};
//   &net12 @WIRE(mode="straight") {#M26:1 %j20};
//   &net12 @WIRE(mode="straight") {%j20 #M27:1};
//   &net12 @WIRE(mode="straight") {%j20 %j19};
//   &net12 @WIRE(mode="straight") {#M15:3 %j13};
//   &net12 @WIRE(mode="straight") {%j13 #M16:3};
//   &net12 @WIRE(mode="straight") {%j13 #M17:1};
//   &net12 @WIRE(mode="straight") {#M17:1 %j18};
//   &net12 @WIRE(mode="straight") {%j18 (86, -49) #M24:2};
//   &net12 @WIRE(mode="straight") {%j19 (86, -14) #M18:2};
//   &VSS @WIRE(mode="straight") {%gnd7:p #M29:3};
//   &VDD @WIRE(mode="straight") {#M30:3 %vdd10:p};
//   &VSS @WIRE(mode="straight") {%gnd8:p #M34:3};
//   &net13 @WIRE(mode="straight") {#M31:1 #M32:1};
//   &net13 @WIRE(mode="straight") {#M31:1 %j23};
//   &net13 @WIRE(mode="straight") {#M21:3 %j15};
//   &net13 @WIRE(mode="straight") {%j15 #M22:3};
//   &net13 @WIRE(mode="straight") {%j15 #M19:1};
//   &net13 @WIRE(mode="straight") {#M19:1 %j23};
//   &net13 @WIRE(mode="straight") {%j17 %j23};
//   &net13 @WIRE(mode="straight") {%j17 (88, -20) #M23:2};
//   &net13 @WIRE(mode="straight") {%j17 #M20:2};
//   &net25 @WIRE(mode="straight") {#M39:1 %j26};
//   &net25 @WIRE(mode="straight") {%j26 #M40:1};
//   &net14 @WIRE(mode="straight") {#M39:3 %j27};
//   &net14 @WIRE(mode="straight") {%j27 #M40:3};
//   &net25 @WIRE(mode="straight") {%j26 #M35:1};
//   &net26 @WIRE(mode="straight") {#M41:1 %j28};
//   &net26 @WIRE(mode="straight") {%j28 #M42:1};
//   &net26 @WIRE(mode="straight") {%j28 #M37:1};
//   &VDD @WIRE(mode="straight") {#M43:3 %vdd13:p};
//   &VDD @WIRE(mode="straight") {#M44:3 %vdd14:p};
//   &VSS @WIRE(mode="straight") {%gnd11:p #M45:3};
//   &VSS @WIRE(mode="straight") {%gnd12:p #M46:3};
//   &VDD @WIRE(mode="straight") {#M47:3 %vdd15:p};
//   &net14 @WIRE(mode="straight") {#M48:1 %j31};
//   &net14 @WIRE(mode="straight") {%j31 #M49:1};
//   &net14 @WIRE(mode="straight") {%j31 %j30};
//   &net14 @WIRE(mode="straight") {%j29 (136, -49) #M46:2};
//   &net14 @WIRE(mode="straight") {%j30 (136, -12) #M43:2};
//   &VSS @WIRE(mode="straight") {%gnd13:p #M51:3};
//   &VDD @WIRE(mode="straight") {#M52:3 %vdd16:p};
//   &VSS @WIRE(mode="straight") {%gnd14:p #M56:3};
//   &net7 @WIRE(mode="straight") {#M44:1 #M46:1};
//   &net7 @WIRE(mode="straight") {#M46:1 %j33};
//   &net7 @WIRE(mode="straight") {#M52:2 (159, -40) %j33};
//   &net7 @WIRE(mode="straight") {#M55:2 (159, -56) %j33};
//   &net11 @WIRE(mode="straight") {#M43:1 #M45:1};
//   &net11 @WIRE(mode="straight") {#M45:1 %j32};
//   &net11 @WIRE(mode="straight") {#M50:2 (159, -23) %j32};
//   &net11 @WIRE(mode="straight") {#M47:2 (159, -7) %j32};
//   &net14 @WIRE(mode="straight") {%j29 %j27};
//   &VDD @WIRE(mode="straight") {#M57:3 %vdd17:p};
//   &net32 @WIRE(mode="straight") {#M47:1 #M57:1};
//   &VDD @WIRE(mode="straight") {#M58:3 %vdd18:p};
//   &net33 @WIRE(mode="straight") {#M58:1 #M52:1};
//   &net14 @WIRE(mode="straight") {%j31 (171, -15) (171, -23) #M59:2};
//   &Q @WIRE(mode="straight") {#M59:1 %j34};
//   &Q @WIRE(mode="straight") {%j34 #M60:1};
//   &VDD @WIRE(mode="straight") {#M59:3 %vdd19:p};
//   &Q @WIRE(mode="straight") {%port31:p %j34};
//   &net9 @WIRE(mode="straight") {#M41:3 %j36};
//   &net9 @WIRE(mode="straight") {%j36 #M42:3};
//   &net9 @WIRE(mode="straight") {%j36 %j38};
//   &net9 @WIRE(mode="straight") {%j37 %j38};
//   &net9 @WIRE(mode="straight") {%j37 (138, -18) #M45:2};
//   &net9 @WIRE(mode="straight") {%j37 #M44:2};
//   &net9 @WIRE(mode="straight") {%j38 #M53:1};
//   &net9 @WIRE(mode="straight") {#M53:1 #M54:1};
//   &net9 @WIRE(mode="straight") {#M53:1 (171, -46) (171, -34) #M60:2};
//   &net6 @WIRE(mode="straight") {#M30:2 %j25};
//   &net6 @WIRE(mode="straight") {#M33:2 (109, -56) %j22};
//   &net6 @WIRE(mode="straight") {%j25 %j22};
//   &net6 @WIRE(mode="straight") {%j25 %j35};
//   &net6 @WIRE(mode="straight") {%j22 #M24:1};
//   &net6 @WIRE(mode="straight") {%j35 (113, -17) #M36:2};
//   &net6 @WIRE(mode="straight") {%j35 (113, -44) #M37:2};
//   &net6 @WIRE(mode="straight") {#M20:1 #M24:1};
//   &net10 @WIRE(mode="straight") {#M28:2 %j24};
//   &net10 @WIRE(mode="straight") {#M25:2 (109, -9) %j21};
//   &net10 @WIRE(mode="straight") {%j21 %j24};
//   &net10 @WIRE(mode="straight") {%j21 #M23:1};
//   &net10 @WIRE(mode="straight") {%j24 %j40};
//   &net10 @WIRE(mode="straight") {%j39 %j40};
//   &net10 @WIRE(mode="straight") {%j39 (111, -13) #M35:2};
//   &net10 @WIRE(mode="straight") {%j40 (111, -48) #M38:2};
//   &net10 @WIRE(mode="straight") {#M18:1 #M23:1};
//   &CLKn @WIRE(mode="straight") {#X6:1 #X5:2};
//   &net0 @WIRE(mode="straight") {#M10:3 #M11:1};
//   &net1 @WIRE(mode="straight") {#M13:3 #M14:1};
//   &net2 @WIRE(mode="straight") {#M27:3 #M28:1};
//   &net3 @WIRE(mode="straight") {#M32:3 #M33:1};
//   &net4 @WIRE(mode="straight") {#M49:3 #M50:1};
//   &net5 @WIRE(mode="straight") {#M54:3 #M55:1};
//   $JUNCTION @ATTACH (93, -47)(p) => %dot1;
//   $JUNCTION @ATTACH (143, -47)(p) => %dot2;
//   $JUNCTION @ATTACH (150, -46)(p) => %dot3;
//   $JUNCTION @ATTACH (93, -18)(p) => %dot4;
//   $JUNCTION @ATTACH (143, -16)(p) => %dot5;
//   $JUNCTION @ATTACH (83, -17)(p) => %dot6;
//   &net12 @WIRE(mode="straight") {%j18 %j19};
//   $JUNCTION @ATTACH (83, -46)(p) => %dot7;
//   $JUNCTION @ATTACH (100, -46)(p) => %dot8;
//   &RST2 @WIRE(mode="straight") {#M19:2 %port10:p};
//   &CLKa @WIRE(mode="straight") {#M21:2 %port11:p};
//   &CLKn @WIRE(mode="straight") {#M22:2 %port12:p};
//   &CLKn @WIRE(mode="straight") {#M26:2 %port13:p};
//   &CLKa @WIRE(mode="straight") {#M27:2 %port14:p};
//   &RST2 @WIRE(mode="straight") {#M29:2 %port15:p};
//   &RST1 @WIRE(mode="straight") {%port2:p #X3:2};
//   &CLKn @WIRE(mode="straight") {#M31:2 %port16:p};
//   &CLKa @WIRE(mode="straight") {#M32:2 %port17:p};
//   &RST1 @WIRE(mode="straight") {#M34:2 %port18:p};
//   &net14 @WIRE(mode="straight") {%j29 %j30};
//   &CLKn @WIRE(mode="straight") {#M39:2 %port19:p};
//   &CLK @WIRE(mode="straight") {#M40:2 %port20:p};
//   &CLKn @WIRE(mode="straight") {#M41:2 %port21:p};
//   &CLK @WIRE(mode="straight") {#M42:2 %port22:p};
//   &RST1 @WIRE(mode="straight") {#M11:2 %port3:p};
//   &CLK @WIRE(mode="straight") {#M48:2 %port23:p};
//   &CLKn @WIRE(mode="straight") {#M49:2 %port24:p};
//   &RST2 @WIRE(mode="straight") {#M51:2 %port25:p};
//   &CLK @WIRE(mode="straight") {#M53:2 %port26:p};
//   &CLKn @WIRE(mode="straight") {#M54:2 %port27:p};
//   &RST1 @WIRE(mode="straight") {#M56:2 %port28:p};
//   &RST1 @WIRE(mode="straight") {#M57:2 %port29:p};
//   &RST1 @WIRE(mode="straight") {#M58:2 %port30:p};
//   &RST2 @WIRE(mode="straight") {%port5:p #X4:2};
//   &RST2 @WIRE(mode="straight") {#M14:2 %port4:p};
//   &CLKa @WIRE(mode="straight") {#M15:2 %port7:p};
//   &CLKn @WIRE(mode="straight") {#M16:2 %port8:p};
//   &RST1 @WIRE(mode="straight") {#M17:2 %port9:p};
//   &VSS @WIRE(mode="straight") {%gnd1:p #M4:3};
//   &VSS @WIRE(mode="straight") {%gnd2:p #M8:3};
//   &VSS @WIRE(mode="straight") {%gnd3:p #M11:3};
//   &VSS @WIRE(mode="straight") {%gnd10:p #M38:3};
//   &VSS @WIRE(mode="straight") {%gnd9:p #M36:3};
//   &VSS @WIRE(mode="straight") {%gnd15:p #M60:3};
//   &VSS @WIRE(mode="straight") {%gnd4:p #M14:3};
//   &CLK @WIRE(mode="straight") {%port32:p #X5:1};
//   &CLKa @WIRE(mode="straight") {%port33:p #X6:2};
//   &VDD @WIRE(mode="straight") {#M35:3 %vdd11:p};
//   &VDD @WIRE(mode="straight") {#M37:3 %vdd12:p};
//   &net15 @WIRE(mode="straight") {#X1:2 #X2:1};
//   &net16 @WIRE(mode="straight") {#M28:3 #M29:1};
//   &net17 @WIRE(mode="straight") {#M33:3 #M34:1};
//   &net18 @WIRE(mode="straight") {#M50:3 #M51:1};
//   &net19 @WIRE(mode="straight") {#M55:3 #M56:1};
//   &net20 @WIRE(mode="straight") {#M3:3 #M4:1};
//   &net21 @WIRE(mode="straight") {#M7:3 #M8:1};
//   &net22 @WIRE(mode="straight") {#M2:1 #M3:1};
//   $JUNCTION @ATTACH (47, -21)(p) => %dot9;
//   &net23 @WIRE(mode="straight") {#M6:1 #M7:1};
//   $JUNCTION @ATTACH (47, -44)(p) => %dot10;
//   &net25 @WIRE(mode="straight") {#M35:1 #M36:1};
//   $JUNCTION @ATTACH (117, -15)(p) => %dot11;
//   &net26 @WIRE(mode="straight") {#M37:1 #M38:1};
//   $JUNCTION @ATTACH (117, -46)(p) => %dot12;
//   &net27 @WIRE(mode="straight") {#M1:1 #M2:3};
//   &net28 @WIRE(mode="straight") {#M5:1 #M6:3};
//   &net30 @WIRE(mode="straight") {#M25:1 #M26:3};
//   &net31 @WIRE(mode="straight") {#M30:1 #M31:3};
//   &net32 @WIRE(mode="straight") {#M47:1 #M48:3};
//   $JUNCTION @ATTACH (150, -9)(p) => %dot13;
//   &net33 @WIRE(mode="straight") {#M52:1 #M53:3};
//   $JUNCTION @ATTACH (150, -42)(p) => %dot14;
//   #M1 @TEXT("\textbf{\textit{M}}_{\textbf{1}}", key="name", dx=0.4, dy=-0.5, halign="start", valign="baseline", size=1.5116);
//   $CANVAS_LABEL @ATTACH(bind="name") #M1::name(label);
//   #M2 @TEXT("\textbf{\textit{M}}_{\textbf{2}}", key="name", dx=0.4, dy=-0.5, halign="start", valign="baseline", size=1.5116);
//   $CANVAS_LABEL @ATTACH(bind="name") #M2::name(label);
//   #M3 @TEXT("\textbf{\textit{M}}_{\textbf{3}}", key="name", dx=0.5, dy=-0.5, halign="start", valign="baseline", size=1.5116);
//   $CANVAS_LABEL @ATTACH(bind="name") #M3::name(label);
//   #M4 @TEXT("\textbf{\textit{M}}_{\textbf{4}}", key="name", dx=0.5, dy=-0.5, halign="start", valign="baseline", size=1.5116);
//   $CANVAS_LABEL @ATTACH(bind="name") #M4::name(label);
//   %vdd1 @TEXT("\textbf{\textit{V}}_{\textbf{DD}}", dx=-1.5, dy=3, size=1.5116) => %power1;
//   $CANVAS_LABEL @ATTACH(bind="port") %power1(label);
//   #M5 @TEXT("\textbf{\textit{M}}_{\textbf{5}}", key="name", dx=0.4, dy=-0.5, halign="start", valign="baseline", size=1.5116);
//   $CANVAS_LABEL @ATTACH(bind="name") #M5::name(label);
//   #M6 @TEXT("\textbf{\textit{M}}_{\textbf{6}}", key="name", dx=0.4, dy=-0.5, halign="start", valign="baseline", size=1.5116);
//   $CANVAS_LABEL @ATTACH(bind="name") #M6::name(label);
//   #M7 @TEXT("\textbf{\textit{M}}_{\textbf{7}}", key="name", dx=0.5, dy=-0.5, halign="start", valign="baseline", size=1.5116);
//   $CANVAS_LABEL @ATTACH(bind="name") #M7::name(label);
//   #M8 @TEXT("\textbf{\textit{M}}_{\textbf{8}}", key="name", dx=0.5, dy=-0.5, halign="start", valign="baseline", size=1.5116);
//   $CANVAS_LABEL @ATTACH(bind="name") #M8::name(label);
//   %vdd2 @TEXT("\textbf{\textit{V}}_{\textbf{DD}}", dx=-1.5, dy=3, size=1.5116) => %power2;
//   $CANVAS_LABEL @ATTACH(bind="port") %power2(label);
//   #X1 @TEXT("\textbf{\textit{X}}_{\textbf{1}}", key="name", dx=-0.5, dy=-2.9, halign="middle", valign="baseline", size=1.5116);
//   $CANVAS_LABEL @ATTACH(bind="name") #X1::name(label);
//   #X2 @TEXT("\textbf{\textit{X}}_{\textbf{2}}", key="name", dx=-0.5, dy=-2.9, halign="middle", valign="baseline", size=1.5116);
//   $CANVAS_LABEL @ATTACH(bind="name") #X2::name(label);
//   %port1 @TEXT("\textbf{\textit{RST}}", key="name", dx=-2, dy=-0.5, halign="end", valign="baseline", size=1.5116);
//   $CANVAS_LABEL @ATTACH(bind="port") %port1::name(label);
//   #X3 @TEXT("\textbf{\textit{X}}_{\textbf{3}}", key="name", dx=-0.5, dy=-2.9, halign="middle", valign="baseline", size=1.5116);
//   $CANVAS_LABEL @ATTACH(bind="name") #X3::name(label);
//   %port2 @TEXT("\textbf{\textit{RST1}}", key="name", dx=0, dy=1.5, halign="start", valign="baseline", size=1.5116);
//   $CANVAS_LABEL @ATTACH(bind="port") %port2::name(label);
//   #M9 @TEXT("\textbf{\textit{M}}_{\textbf{9}}", key="name", dx=0.4, dy=-0.5, halign="start", valign="baseline", size=1.5116);
//   $CANVAS_LABEL @ATTACH(bind="name") #M9::name(label);
//   #M10 @TEXT("\textbf{\textit{M}}_{\textbf{10}}", key="name", dx=0.5, dy=-0.5, halign="start", valign="baseline", size=1.5116);
//   $CANVAS_LABEL @ATTACH(bind="name") #M10::name(label);
//   #M11 @TEXT("\textbf{\textit{M}}_{\textbf{11}}", key="name", dx=0.5, dy=-0.5, halign="start", valign="baseline", size=1.5116);
//   $CANVAS_LABEL @ATTACH(bind="name") #M11::name(label);
//   %vdd3 @TEXT("\textbf{\textit{V}}_{\textbf{DD}}", dx=-1.5, dy=3, size=1.5116) => %power3;
//   $CANVAS_LABEL @ATTACH(bind="port") %power3(label);
//   %port3 @TEXT("\textbf{\textit{RST1}}", key="name", dx=0.5, dy=1, halign="end", valign="baseline", size=1.5116);
//   $CANVAS_LABEL @ATTACH(bind="port") %port3::name(label);
//   #M12 @TEXT("\textbf{\textit{M}}_{\textbf{12}}", key="name", dx=0.4, dy=-0.5, halign="start", valign="baseline", size=1.5116);
//   $CANVAS_LABEL @ATTACH(bind="name") #M12::name(label);
//   #M13 @TEXT("\textbf{\textit{M}}_{\textbf{13}}", key="name", dx=0.5, dy=-0.5, halign="start", valign="baseline", size=1.5116);
//   $CANVAS_LABEL @ATTACH(bind="name") #M13::name(label);
//   #M14 @TEXT("\textbf{\textit{M}}_{\textbf{14}}", key="name", dx=0.5, dy=-0.5, halign="start", valign="baseline", size=1.5116);
//   $CANVAS_LABEL @ATTACH(bind="name") #M14::name(label);
//   %vdd4 @TEXT("\textbf{\textit{V}}_{\textbf{DD}}", dx=-1.5, dy=3, size=1.5116) => %power4;
//   $CANVAS_LABEL @ATTACH(bind="port") %power4(label);
//   %port4 @TEXT("\textbf{\textit{RST2}}", key="name", dx=0.5, dy=1, halign="end", valign="baseline", size=1.5116);
//   $CANVAS_LABEL @ATTACH(bind="port") %port4::name(label);
//   #X4 @TEXT("\textbf{\textit{X}}_{\textbf{4}}", key="name", dx=-0.5, dy=-2.9, halign="middle", valign="baseline", size=1.5116);
//   $CANVAS_LABEL @ATTACH(bind="name") #X4::name(label);
//   %port5 @TEXT("\textbf{\textit{RST2}}", key="name", dx=0.5, dy=-2, halign="start", valign="baseline", size=1.5116);
//   $CANVAS_LABEL @ATTACH(bind="port") %port5::name(label);
//   %port6 @TEXT("\textbf{\textit{D}}", key="name", dx=-2, dy=-0.5, halign="end", valign="baseline", size=1.5116);
//   $CANVAS_LABEL @ATTACH(bind="port") %port6::name(label);
//   #M15 @TEXT("\textbf{\textit{M}}_{\textbf{15}}", key="name", dx=-3, dy=1, halign="middle", valign="baseline", size=1.5116);
//   $CANVAS_LABEL @ATTACH(bind="name") #M15::name(label);
//   #M16 @TEXT("\textbf{\textit{M}}_{\textbf{16}}", key="name", dx=-2.5, dy=-2, halign="middle", valign="baseline", size=1.5116);
//   $CANVAS_LABEL @ATTACH(bind="name") #M16::name(label);
//   %port7 @TEXT("\textbf{\textit{CLKa}}", key="name", dx=0, dy=1.9, halign="middle", valign="baseline", size=1.5116);
//   $CANVAS_LABEL @ATTACH(bind="port") %port7::name(label);
//   %port8 @TEXT("\textbf{\textit{CLKn}}", key="name", dx=0, dy=-2.8, halign="middle", valign="baseline", size=1.5116);
//   $CANVAS_LABEL @ATTACH(bind="port") %port8::name(label);
//   #M17 @TEXT("\textbf{\textit{M}}_{\textbf{17}}", key="name", dx=1.5, dy=-0.5, halign="middle", valign="baseline", size=1.5116);
//   $CANVAS_LABEL @ATTACH(bind="name") #M17::name(label);
//   %port9 @TEXT("\textbf{\textit{RST1}}", key="name", dx=0, dy=0.5, halign="end", valign="baseline", size=1.5116);
//   $CANVAS_LABEL @ATTACH(bind="port") %port9::name(label);
//   %vdd5 @TEXT("\textbf{\textit{V}}_{\textbf{DD}}", dx=-1.5, dy=3, size=1.5116) => %power5;
//   $CANVAS_LABEL @ATTACH(bind="port") %power5(label);
//   #M18 @TEXT("\textbf{\textit{M}}_{\textbf{18}}", key="name", dx=2, dy=0, halign="middle", valign="baseline", size=1.5116);
//   $CANVAS_LABEL @ATTACH(bind="name") #M18::name(label);
//   %vdd6 @TEXT("\textbf{\textit{V}}_{\textbf{DD}}", dx=-1.5, dy=3, size=1.5116) => %power6;
//   $CANVAS_LABEL @ATTACH(bind="port") %power6(label);
//   #M19 @TEXT("\textbf{\textit{M}}_{\textbf{19}}", key="name", dx=1.5, dy=-1, halign="middle", valign="baseline", size=1.5116);
//   $CANVAS_LABEL @ATTACH(bind="name") #M19::name(label);
//   %port10 @TEXT("\textbf{\textit{RST2}}", key="name", dx=0, dy=0.5, halign="end", valign="baseline", size=1.5116);
//   $CANVAS_LABEL @ATTACH(bind="port") %port10::name(label);
//   %vdd7 @TEXT("\textbf{\textit{V}}_{\textbf{DD}}", dx=-1.5, dy=3, size=1.5116) => %power7;
//   $CANVAS_LABEL @ATTACH(bind="port") %power7(label);
//   #M20 @TEXT("\textbf{\textit{M}}_{\textbf{20}}", key="name", dx=2, dy=0, halign="middle", valign="baseline", size=1.5116);
//   $CANVAS_LABEL @ATTACH(bind="name") #M20::name(label);
//   %vdd8 @TEXT("\textbf{\textit{V}}_{\textbf{DD}}", dx=-1.5, dy=3, size=1.5116) => %power8;
//   $CANVAS_LABEL @ATTACH(bind="port") %power8(label);
//   #M21 @TEXT("\textbf{\textit{M}}_{\textbf{21}}", key="name", dx=-3, dy=1, halign="middle", valign="baseline", size=1.5116);
//   $CANVAS_LABEL @ATTACH(bind="name") #M21::name(label);
//   #M22 @TEXT("\textbf{\textit{M}}_{\textbf{22}}", key="name", dx=-2.5, dy=-2, halign="middle", valign="baseline", size=1.5116);
//   $CANVAS_LABEL @ATTACH(bind="name") #M22::name(label);
//   %port11 @TEXT("\textbf{\textit{CLKa}}", key="name", dx=0, dy=1.9, halign="middle", valign="baseline", size=1.5116);
//   $CANVAS_LABEL @ATTACH(bind="port") %port11::name(label);
//   %port12 @TEXT("\textbf{\textit{CLKn}}", key="name", dx=0, dy=-2.8, halign="middle", valign="baseline", size=1.5116);
//   $CANVAS_LABEL @ATTACH(bind="port") %port12::name(label);
//   #M23 @TEXT("\textbf{\textit{M}}_{\textbf{23}}", key="name", dx=2, dy=0, halign="middle", valign="baseline", size=1.5116);
//   $CANVAS_LABEL @ATTACH(bind="name") #M23::name(label);
//   #M24 @TEXT("\textbf{\textit{M}}_{\textbf{24}}", key="name", dx=2, dy=0, halign="middle", valign="baseline", size=1.5116);
//   $CANVAS_LABEL @ATTACH(bind="name") #M24::name(label);
//   #M25 @TEXT("\textbf{\textit{M}}_{\textbf{25}}", key="name", dx=-2, dy=0, halign="middle", valign="baseline", size=1.5116);
//   $CANVAS_LABEL @ATTACH(bind="name") #M25::name(label);
//   #M26 @TEXT("\textbf{\textit{M}}_{\textbf{26}}", key="name", dx=-1.5, dy=-0.5, halign="middle", valign="baseline", size=1.5116);
//   $CANVAS_LABEL @ATTACH(bind="name") #M26::name(label);
//   #M27 @TEXT("\textbf{\textit{M}}_{\textbf{27}}", key="name", dx=-0.5, dy=-0.5, halign="end", valign="baseline", size=1.5116);
//   $CANVAS_LABEL @ATTACH(bind="name") #M27::name(label);
//   #M28 @TEXT("\textbf{\textit{M}}_{\textbf{28}}", key="name", dx=-0.5, dy=-0.5, halign="end", valign="baseline", size=1.5116);
//   $CANVAS_LABEL @ATTACH(bind="name") #M28::name(label);
//   %vdd9 @TEXT("\textbf{\textit{V}}_{\textbf{DD}}", dx=-1.5, dy=3, size=1.5116) => %power9;
//   $CANVAS_LABEL @ATTACH(bind="port") %power9(label);
//   %port13 @TEXT("\textbf{\textit{CLKn}}", key="name", dx=1.5, dy=-1, halign="start", valign="baseline", size=1.5116);
//   $CANVAS_LABEL @ATTACH(bind="port") %port13::name(label);
//   %port14 @TEXT("\textbf{\textit{CLKa}}", key="name", dx=1.5, dy=-0.5, halign="start", valign="baseline", size=1.5116);
//   $CANVAS_LABEL @ATTACH(bind="port") %port14::name(label);
//   #M29 @TEXT("\textbf{\textit{M}}_{\textbf{29}}", key="name", dx=-0.5, dy=-0.5, halign="end", valign="baseline", size=1.5116);
//   $CANVAS_LABEL @ATTACH(bind="name") #M29::name(label);
//   %port15 @TEXT("\textbf{\textit{RST2}}", key="name", dx=1.5, dy=-0.5, halign="start", valign="baseline", size=1.5116);
//   $CANVAS_LABEL @ATTACH(bind="port") %port15::name(label);
//   #M30 @TEXT("\textbf{\textit{M}}_{\textbf{30}}", key="name", dx=-2, dy=0, halign="middle", valign="baseline", size=1.5116);
//   $CANVAS_LABEL @ATTACH(bind="name") #M30::name(label);
//   #M31 @TEXT("\textbf{\textit{M}}_{\textbf{31}}", key="name", dx=-1.5, dy=-0.5, halign="middle", valign="baseline", size=1.5116);
//   $CANVAS_LABEL @ATTACH(bind="name") #M31::name(label);
//   #M32 @TEXT("\textbf{\textit{M}}_{\textbf{32}}", key="name", dx=-0.5, dy=-0.5, halign="end", valign="baseline", size=1.5116);
//   $CANVAS_LABEL @ATTACH(bind="name") #M32::name(label);
//   #M33 @TEXT("\textbf{\textit{M}}_{\textbf{33}}", key="name", dx=-0.5, dy=-0.5, halign="end", valign="baseline", size=1.5116);
//   $CANVAS_LABEL @ATTACH(bind="name") #M33::name(label);
//   %vdd10 @TEXT("\textbf{\textit{V}}_{\textbf{DD}}", dx=-1.5, dy=3, size=1.5116) => %power10;
//   $CANVAS_LABEL @ATTACH(bind="port") %power10(label);
//   %port16 @TEXT("\textbf{\textit{CLKn}}", key="name", dx=1.5, dy=-1, halign="start", valign="baseline", size=1.5116);
//   $CANVAS_LABEL @ATTACH(bind="port") %port16::name(label);
//   %port17 @TEXT("\textbf{\textit{CLKa}}", key="name", dx=1.5, dy=-0.5, halign="start", valign="baseline", size=1.5116);
//   $CANVAS_LABEL @ATTACH(bind="port") %port17::name(label);
//   #M34 @TEXT("\textbf{\textit{M}}_{\textbf{34}}", key="name", dx=-0.5, dy=-0.5, halign="end", valign="baseline", size=1.5116);
//   $CANVAS_LABEL @ATTACH(bind="name") #M34::name(label);
//   %port18 @TEXT("\textbf{\textit{RST1}}", key="name", dx=1.5, dy=-0.5, halign="start", valign="baseline", size=1.5116);
//   $CANVAS_LABEL @ATTACH(bind="port") %port18::name(label);
//   #M35 @TEXT("\textbf{\textit{M}}_{\textbf{35}}", key="name", dx=2, dy=0, halign="middle", valign="baseline", size=1.5116);
//   $CANVAS_LABEL @ATTACH(bind="name") #M35::name(label);
//   #M37 @TEXT("\textbf{\textit{M}}_{\textbf{37}}", key="name", dx=2, dy=0, halign="middle", valign="baseline", size=1.5116);
//   $CANVAS_LABEL @ATTACH(bind="name") #M37::name(label);
//   %vdd11 @TEXT("\textbf{\textit{V}}_{\textbf{DD}}", dx=-1.5, dy=3, size=1.5116) => %power11;
//   $CANVAS_LABEL @ATTACH(bind="port") %power11(label);
//   %vdd12 @TEXT("\textbf{\textit{V}}_{\textbf{DD}}", dx=-1.5, dy=3, size=1.5116) => %power12;
//   $CANVAS_LABEL @ATTACH(bind="port") %power12(label);
//   #M39 @TEXT("\textbf{\textit{M}}_{\textbf{39}}", key="name", dx=-3, dy=1, halign="middle", valign="baseline", size=1.5116);
//   $CANVAS_LABEL @ATTACH(bind="name") #M39::name(label);
//   #M40 @TEXT("\textbf{\textit{M}}_{\textbf{40}}", key="name", dx=-2.5, dy=-2, halign="middle", valign="baseline", size=1.5116);
//   $CANVAS_LABEL @ATTACH(bind="name") #M40::name(label);
//   %port19 @TEXT("\textbf{\textit{CLKn}}", key="name", dx=0, dy=1.9, halign="middle", valign="baseline", size=1.5116);
//   $CANVAS_LABEL @ATTACH(bind="port") %port19::name(label);
//   %port20 @TEXT("\textbf{\textit{CLK}}", key="name", dx=0, dy=-2.8, halign="middle", valign="baseline", size=1.5116);
//   $CANVAS_LABEL @ATTACH(bind="port") %port20::name(label);
//   #M41 @TEXT("\textbf{\textit{M}}_{\textbf{41}}", key="name", dx=-3, dy=1, halign="middle", valign="baseline", size=1.5116);
//   $CANVAS_LABEL @ATTACH(bind="name") #M41::name(label);
//   #M42 @TEXT("\textbf{\textit{M}}_{\textbf{42}}", key="name", dx=-2.5, dy=-2, halign="middle", valign="baseline", size=1.5116);
//   $CANVAS_LABEL @ATTACH(bind="name") #M42::name(label);
//   %port21 @TEXT("\textbf{\textit{CLKn}}", key="name", dx=0, dy=1.9, halign="middle", valign="baseline", size=1.5116);
//   $CANVAS_LABEL @ATTACH(bind="port") %port21::name(label);
//   %port22 @TEXT("\textbf{\textit{CLK}}", key="name", dx=0, dy=-2.8, halign="middle", valign="baseline", size=1.5116);
//   $CANVAS_LABEL @ATTACH(bind="port") %port22::name(label);
//   #M43 @TEXT("\textbf{\textit{M}}_{\textbf{43}}", key="name", dx=2, dy=0, halign="middle", valign="baseline", size=1.5116);
//   $CANVAS_LABEL @ATTACH(bind="name") #M43::name(label);
//   %vdd13 @TEXT("\textbf{\textit{V}}_{\textbf{DD}}", dx=-1.5, dy=3, size=1.5116) => %power13;
//   $CANVAS_LABEL @ATTACH(bind="port") %power13(label);
//   #M44 @TEXT("\textbf{\textit{M}}_{\textbf{44}}", key="name", dx=1.5, dy=-0.5, halign="middle", valign="baseline", size=1.5116);
//   $CANVAS_LABEL @ATTACH(bind="name") #M44::name(label);
//   %vdd14 @TEXT("\textbf{\textit{V}}_{\textbf{DD}}", dx=-1.5, dy=3, size=1.5116) => %power14;
//   $CANVAS_LABEL @ATTACH(bind="port") %power14(label);
//   #M45 @TEXT("\textbf{\textit{M}}_{\textbf{45}}", key="name", dx=2, dy=0, halign="middle", valign="baseline", size=1.5116);
//   $CANVAS_LABEL @ATTACH(bind="name") #M45::name(label);
//   #M46 @TEXT("\textbf{\textit{M}}_{\textbf{46}}", key="name", dx=2, dy=0, halign="middle", valign="baseline", size=1.5116);
//   $CANVAS_LABEL @ATTACH(bind="name") #M46::name(label);
//   #M47 @TEXT("\textbf{\textit{M}}_{\textbf{47}}", key="name", dx=-2, dy=0, halign="middle", valign="baseline", size=1.5116);
//   $CANVAS_LABEL @ATTACH(bind="name") #M47::name(label);
//   #M48 @TEXT("\textbf{\textit{M}}_{\textbf{48}}", key="name", dx=-1.5, dy=-0.5, halign="middle", valign="baseline", size=1.5116);
//   $CANVAS_LABEL @ATTACH(bind="name") #M48::name(label);
//   #M49 @TEXT("\textbf{\textit{M}}_{\textbf{49}}", key="name", dx=-0.5, dy=-0.5, halign="end", valign="baseline", size=1.5116);
//   $CANVAS_LABEL @ATTACH(bind="name") #M49::name(label);
//   #M50 @TEXT("\textbf{\textit{M}}_{\textbf{50}}", key="name", dx=-0.5, dy=-0.5, halign="end", valign="baseline", size=1.5116);
//   $CANVAS_LABEL @ATTACH(bind="name") #M50::name(label);
//   %vdd15 @TEXT("\textbf{\textit{V}}_{\textbf{DD}}", dx=-1.5, dy=3, size=1.5116) => %power15;
//   $CANVAS_LABEL @ATTACH(bind="port") %power15(label);
//   %port23 @TEXT("\textbf{\textit{CLK}}", key="name", dx=1.5, dy=-1, halign="start", valign="baseline", size=1.5116);
//   $CANVAS_LABEL @ATTACH(bind="port") %port23::name(label);
//   %port24 @TEXT("\textbf{\textit{CLKn}}", key="name", dx=1.5, dy=-0.5, halign="start", valign="baseline", size=1.5116);
//   $CANVAS_LABEL @ATTACH(bind="port") %port24::name(label);
//   #M51 @TEXT("\textbf{\textit{M}}_{\textbf{51}}", key="name", dx=-0.5, dy=-0.5, halign="end", valign="baseline", size=1.5116);
//   $CANVAS_LABEL @ATTACH(bind="name") #M51::name(label);
//   %port25 @TEXT("\textbf{\textit{RST2}}", key="name", dx=1.5, dy=-0.5, halign="start", valign="baseline", size=1.5116);
//   $CANVAS_LABEL @ATTACH(bind="port") %port25::name(label);
//   #M52 @TEXT("\textbf{\textit{M}}_{\textbf{52}}", key="name", dx=-2, dy=0, halign="middle", valign="baseline", size=1.5116);
//   $CANVAS_LABEL @ATTACH(bind="name") #M52::name(label);
//   #M53 @TEXT("\textbf{\textit{M}}_{\textbf{53}}", key="name", dx=-2, dy=0, halign="middle", valign="baseline", size=1.5116);
//   $CANVAS_LABEL @ATTACH(bind="name") #M53::name(label);
//   #M54 @TEXT("\textbf{\textit{M}}_{\textbf{54}}", key="name", dx=-0.5, dy=-0.5, halign="end", valign="baseline", size=1.5116);
//   $CANVAS_LABEL @ATTACH(bind="name") #M54::name(label);
//   #M55 @TEXT("\textbf{\textit{M}}_{\textbf{55}}", key="name", dx=-0.5, dy=-0.5, halign="end", valign="baseline", size=1.5116);
//   $CANVAS_LABEL @ATTACH(bind="name") #M55::name(label);
//   %vdd16 @TEXT("\textbf{\textit{V}}_{\textbf{DD}}", dx=-1.5, dy=3, size=1.5116) => %power16;
//   $CANVAS_LABEL @ATTACH(bind="port") %power16(label);
//   %port26 @TEXT("\textbf{\textit{CLK}}", key="name", dx=1.5, dy=-1, halign="start", valign="baseline", size=1.5116);
//   $CANVAS_LABEL @ATTACH(bind="port") %port26::name(label);
//   %port27 @TEXT("\textbf{\textit{CLKn}}", key="name", dx=1.5, dy=-0.5, halign="start", valign="baseline", size=1.5116);
//   $CANVAS_LABEL @ATTACH(bind="port") %port27::name(label);
//   #M56 @TEXT("\textbf{\textit{M}}_{\textbf{56}}", key="name", dx=-0.5, dy=-0.5, halign="end", valign="baseline", size=1.5116);
//   $CANVAS_LABEL @ATTACH(bind="name") #M56::name(label);
//   %port28 @TEXT("\textbf{\textit{RST1}}", key="name", dx=1.5, dy=-0.5, halign="start", valign="baseline", size=1.5116);
//   $CANVAS_LABEL @ATTACH(bind="port") %port28::name(label);
//   #M57 @TEXT("\textbf{\textit{M}}_{\textbf{57}}", key="name", dx=-2, dy=0, halign="middle", valign="baseline", size=1.5116);
//   $CANVAS_LABEL @ATTACH(bind="name") #M57::name(label);
//   %vdd17 @TEXT("\textbf{\textit{V}}_{\textbf{DD}}", dx=-1.5, dy=3, size=1.5116) => %power17;
//   $CANVAS_LABEL @ATTACH(bind="port") %power17(label);
//   %port29 @TEXT("\textbf{\textit{RST1}}", key="name", dx=2, dy=-0.5, halign="start", valign="baseline", size=1.5116);
//   $CANVAS_LABEL @ATTACH(bind="port") %port29::name(label);
//   #M58 @TEXT("\textbf{\textit{M}}_{\textbf{58}}", key="name", dx=-2, dy=0, halign="middle", valign="baseline", size=1.5116);
//   $CANVAS_LABEL @ATTACH(bind="name") #M58::name(label);
//   %vdd18 @TEXT("\textbf{\textit{V}}_{\textbf{DD}}", dx=-1.5, dy=3, size=1.5116) => %power18;
//   $CANVAS_LABEL @ATTACH(bind="port") %power18(label);
//   %port30 @TEXT("\textbf{\textit{RST1}}", key="name", dx=-1, dy=1.5, halign="start", valign="baseline", size=1.5116);
//   $CANVAS_LABEL @ATTACH(bind="port") %port30::name(label);
//   #M59 @TEXT("\textbf{\textit{M}}_{\textbf{59}}", key="name", dx=1.5, dy=-0.5, halign="middle", valign="baseline", size=1.5116);
//   $CANVAS_LABEL @ATTACH(bind="name") #M59::name(label);
//   #M60 @TEXT("\textbf{\textit{M}}_{\textbf{60}}", key="name", dx=0.5, dy=-0.5, halign="start", valign="baseline", size=1.5116);
//   $CANVAS_LABEL @ATTACH(bind="name") #M60::name(label);
//   %vdd19 @TEXT("\textbf{\textit{V}}_{\textbf{DD}}", dx=-1.5, dy=3, size=1.5116) => %power19;
//   $CANVAS_LABEL @ATTACH(bind="port") %power19(label);
//   %port31 @TEXT("\textbf{\textit{Q}}", key="name", dx=2, dy=-0.5, halign="start", valign="baseline", size=1.5116);
//   $CANVAS_LABEL @ATTACH(bind="port") %port31::name(label);
//   #M36 @TEXT("\textbf{\textit{M}}_{\textbf{36}}", key="name", dx=2, dy=0, halign="middle", valign="baseline", size=1.5116);
//   $CANVAS_LABEL @ATTACH(bind="name") #M36::name(label);
//   #M38 @TEXT("\textbf{\textit{M}}_{\textbf{38}}", key="name", dx=2, dy=0, halign="middle", valign="baseline", size=1.5116);
//   $CANVAS_LABEL @ATTACH(bind="name") #M38::name(label);
//   #X5 @TEXT("\textbf{\textit{X}}_{\textbf{5}}", key="name", dx=-0.5, dy=-2.9, halign="middle", valign="baseline", size=1.5116);
//   $CANVAS_LABEL @ATTACH(bind="name") #X5::name(label);
//   #X6 @TEXT("\textbf{\textit{X}}_{\textbf{6}}", key="name", dx=-0.5, dy=-2.9, halign="middle", valign="baseline", size=1.5116);
//   $CANVAS_LABEL @ATTACH(bind="name") #X6::name(label);
//   %port32 @TEXT("\textbf{\textit{CLK}}", key="name", dx=-2, dy=-0.5, halign="end", valign="baseline", size=1.5116);
//   $CANVAS_LABEL @ATTACH(bind="port") %port32::name(label);
//   %port33 @TEXT("\textbf{\textit{CLKa}}", key="name", dx=2, dy=-0.5, halign="start", valign="baseline", size=1.5116);
//   $CANVAS_LABEL @ATTACH(bind="port") %port33::name(label);
//   &CLKn @TEXT("\textbf{\textit{CLKn}}", size=1.5116) => @PLACE(80.5, -5) => %label1;
//   $CANVAS_LABEL @ATTACH(bind="net") %label1(label)
// }
ends dut
