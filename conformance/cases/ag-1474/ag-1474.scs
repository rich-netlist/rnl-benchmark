simulator lang=spectre
// @RNL(type="header") {
//   @VERSION("0.4");
//   @USE-PACKAGE(name="rnl-std-style", version="0.4");
//   @USE-PACKAGE(name="rnl-std-basic", version="0.4");
//   @USE-PACKAGE(name="rnl-std-semiconductors", version="0.4");
//   @USE-PACKAGE(name="rnl-std-no-labels", version="0.4");
//   @USE-PACKAGE(name="analog-canvas-extensions", version="0.7")
// }

subckt opamp (VDD VSS VB4 VB2 VB1 INP INN OUT)
M1 (net7 VB2 VDD VDD) sky130_fd_pr__pfet_01v8 l=0.15 w=1 nf=1 m=1
M10 (net8 VB4 net6 VSS) sky130_fd_pr__nfet_01v8 l=0.15 w=1 nf=1 m=1
M11 (OUT VB4 net3 VSS) sky130_fd_pr__nfet_01v8 l=0.15 w=1 nf=1 m=1
M12 (net0 net5 VSS VSS) sky130_fd_pr__nfet_01v8 l=0.15 w=1 nf=1 m=1
M13 (net2 net5 VSS VSS) sky130_fd_pr__nfet_01v8 l=0.15 w=1 nf=1 m=1
M14 (net6 net8 VSS VSS) sky130_fd_pr__nfet_01v8 l=0.15 w=1 nf=1 m=1
M15 (net3 net8 VSS VSS) sky130_fd_pr__nfet_01v8 l=0.15 w=1 nf=1 m=1
M2 (net5 INP net7 net9) sky130_fd_pr__pfet_01v8 l=0.15 w=1 nf=1 m=1
M3 (net8 INN net7 net9) sky130_fd_pr__pfet_01v8 l=0.15 w=1 nf=1 m=1
M4 (net4 VP VDD VDD) sky130_fd_pr__pfet_01v8 l=0.15 w=1 nf=1 m=1
M5 (net1 VP VDD VDD) sky130_fd_pr__pfet_01v8 l=0.15 w=1 nf=1 m=1
M6 (VP VB1 net4 VDD) sky130_fd_pr__pfet_01v8 l=0.15 w=1 nf=1 m=1
M7 (OUT VB1 net1 VDD) sky130_fd_pr__pfet_01v8 l=0.15 w=1 nf=1 m=1
M8 (VP VB4 net0 VSS) sky130_fd_pr__nfet_01v8 l=0.15 w=1 nf=1 m=1
M9 (net5 VB4 net2 VSS) sky130_fd_pr__nfet_01v8 l=0.15 w=1 nf=1 m=1
// @RNL(author="analog-canvas") {
//   %opamp_SYMBOL = @DEFINE-SYMBOL(box=[-6, -7, 6, 7]) {
//     (0, 7) @PIN(terminal="VDD", label="\textbf{\textit{V}}_{\textbf{DD}}", direction="up");
//     (3, -7) @PIN(terminal="VB4", label="\textbf{\textit{V}}_{\textbf{B4}}", direction="down");
//     (0, -7) @PIN(terminal="VB2", label="\textbf{\textit{V}}_{\textbf{B2}}", direction="down");
//     (-3, -7) @PIN(terminal="VB1", label="\textbf{\textit{V}}_{\textbf{B1}}", direction="down");
//     (-6, -2) @PIN(terminal="INP", label="\textbf{\textit{INP}}", direction="left");
//     (-6, 2) @PIN(terminal="INN", label="\textbf{\textit{INN}}", direction="left");
//     (6, 0) @PIN(terminal="OUT", label="\textbf{\textit{OUT}}", direction="right");
//     (0, 0) @RECTANGLE(width=10, height=12);
//     @LINE {(0, 7) (0, 6)};
//     @LINE {(3, -7) (3, -6)};
//     @LINE {(0, -7) (0, -6)};
//     @LINE {(-3, -7) (-3, -6)};
//     @LINE {(-6, -2) (-5, -2)};
//     @LINE {(-6, 2) (-5, 2)};
//     @LINE {(6, 0) (5, 0)}
//   };
//   # @SET-SYMBOL %opamp_SYMBOL;
//   $CANVAS_TYPESETTING @ATTACH(subscript_italic=false) #(level);
//   #M1 @SET-SYMBOL(terminals=[[1, "d"], [2, "g"], [3, "s"]]) $PMOS => @PLACE(29, -4) => @ORIENT("R0");
//   #M2 @SET-SYMBOL(terminals=[[1, "d"], [2, "g"], [3, "s"], [4, "b"]]) $CANVAS_PMOS_4TERM => @PLACE(23, -12) => @ORIENT("R0");
//   #M3 @SET-SYMBOL(terminals=[[1, "d"], [2, "g"], [3, "s"], [4, "b"]]) $CANVAS_PMOS_4TERM => @PLACE(39, -12) => @ORIENT("MY");
//   #M4 @SET-SYMBOL(terminals=[[1, "d"], [2, "g"], [3, "s"]]) $PMOS => @PLACE(11, -4) => @ORIENT("R0");
//   #M6 @SET-SYMBOL(terminals=[[1, "d"], [2, "g"], [3, "s"]]) $PMOS => @PLACE(11, -10) => @ORIENT("MY");
//   #M5 @SET-SYMBOL(terminals=[[1, "d"], [2, "g"], [3, "s"]]) $PMOS => @PLACE(51, -4) => @ORIENT("MY");
//   #M7 @SET-SYMBOL(terminals=[[1, "d"], [2, "g"], [3, "s"]]) $PMOS => @PLACE(51, -10) => @ORIENT("MY");
//   #M8 @SET-SYMBOL(terminals=[[1, "d"], [2, "g"], [3, "s"]]) $NMOS => @PLACE(11, -20) => @ORIENT("R0");
//   #M12 @SET-SYMBOL(terminals=[[1, "d"], [2, "g"], [3, "s"]]) $NMOS => @PLACE(11, -26) => @ORIENT("MY");
//   #M9 @SET-SYMBOL(terminals=[[1, "d"], [2, "g"], [3, "s"]]) $NMOS => @PLACE(23, -20) => @ORIENT("MY");
//   #M13 @SET-SYMBOL(terminals=[[1, "d"], [2, "g"], [3, "s"]]) $NMOS => @PLACE(23, -26) => @ORIENT("R0");
//   #M10 @SET-SYMBOL(terminals=[[1, "d"], [2, "g"], [3, "s"]]) $NMOS => @PLACE(39, -20) => @ORIENT("R0");
//   #M14 @SET-SYMBOL(terminals=[[1, "d"], [2, "g"], [3, "s"]]) $NMOS => @PLACE(39, -26) => @ORIENT("MY");
//   #M11 @SET-SYMBOL(terminals=[[1, "d"], [2, "g"], [3, "s"]]) $NMOS => @PLACE(51, -20) => @ORIENT("MY");
//   #M15 @SET-SYMBOL(terminals=[[1, "d"], [2, "g"], [3, "s"]]) $NMOS => @PLACE(51, -26) => @ORIENT("R0");
//   $SUPPLY @ATTACH &VDD(p) => @SET-SYMBOL $SUPPLY_SYMBOL => @PLACE(25, 0) => @ORIENT("R0") => %vdd1;
//   $GROUND @ATTACH &VSS(p) => @SET-SYMBOL $GROUND_SYMBOL => @PLACE(11, -30) => @ORIENT("R0") => %gnd1;
//   $GROUND @ATTACH &VSS(p) => @SET-SYMBOL $GROUND_SYMBOL => @PLACE(23, -30) => @ORIENT("R0") => %gnd2;
//   $GROUND @ATTACH &VSS(p) => @SET-SYMBOL $GROUND_SYMBOL => @PLACE(39, -30) => @ORIENT("R0") => %gnd3;
//   $GROUND @ATTACH &VSS(p) => @SET-SYMBOL $GROUND_SYMBOL => @PLACE(51, -30) => @ORIENT("R0") => %gnd4;
//   $IO_PORT @ATTACH &VB4(p) => @SET-SYMBOL $IO_PORT_SYMBOL => @PLACE(5, -20) => @ORIENT("R0") => %port1;
//   $IO_PORT @ATTACH &VB2(p) => @SET-SYMBOL $IO_PORT_SYMBOL => @PLACE(23, -4) => @ORIENT("R0") => %port2;
//   $IO_PORT @ATTACH &VB1(p) => @SET-SYMBOL $IO_PORT_SYMBOL => @PLACE(57, -10) => @ORIENT("MY") => %port3;
//   $IO_PORT @ATTACH &INP(p) => @SET-SYMBOL $IO_PORT_SYMBOL => @PLACE(17, -12) => @ORIENT("R0") => %port4;
//   $IO_PORT @ATTACH &INN(p) => @SET-SYMBOL $IO_PORT_SYMBOL => @PLACE(44, -12) => @ORIENT("MY") => %port5;
//   $IO_PORT @ATTACH &OUT(p) => @SET-SYMBOL $IO_PORT_SYMBOL => @PLACE(58, -15) => @ORIENT("MY") => %port6;
//   %j1 = (29, 0);
//   %j2 = (11, -15);
//   %j3 = (29, -10);
//   %j4 = (23, -16);
//   %j5 = (17, -26);
//   %j6 = (39, -16);
//   %j7 = (45, -26);
//   %j8 = (56, -20);
//   %j9 = (16, -10);
//   %j10 = (56, -4);
//   %j11 = (51, -15);
//   &VDD @WIRE(mode="straight") {%vdd1::pin (11, 0) #M4:3};
//   &VDD @WIRE(mode="straight") {%vdd1::pin %j1};
//   &VDD @WIRE(mode="straight") {%j1 (51, 0) #M5:3};
//   &VDD @WIRE(mode="straight") {#M1:3 %j1};
//   &net4 @WIRE(mode="straight") {#M4:1 #M6:3};
//   &VP @WIRE(mode="straight") {#M6:1 %j2};
//   &VP @WIRE(mode="straight") {%j2 #M8:1};
//   &VP @WIRE(mode="straight") {#M4:2 (7, -4) (7, -15) %j2} => %wire1;
//   &net0 @WIRE(mode="straight") {#M8:3 #M12:1};
//   &VSS @WIRE(mode="straight") {#M12:3 %gnd1::pin};
//   &net1 @WIRE(mode="straight") {#M5:1 #M7:3};
//   &OUT @WIRE(mode="straight") {#M7:1 %j11};
//   &OUT @WIRE(mode="straight") {%j11 #M11:1};
//   &net3 @WIRE(mode="straight") {#M11:3 #M15:1};
//   &VSS @WIRE(mode="straight") {#M15:3 %gnd4::pin};
//   &net7 @WIRE(mode="straight") {#M2:3 %j3};
//   &net7 @WIRE(mode="straight") {%j3 #M3:3};
//   &net7 @WIRE(mode="straight") {#M1:1 %j3};
//   &net9 @WIRE(mode="straight", linestyle="dashed") {#M2:4 #M3:4};
//   &net5 @WIRE(mode="straight") {#M2:1 %j4};
//   &net5 @WIRE(mode="straight") {%j4 #M9:1};
//   &net8 @WIRE(mode="straight") {#M3:1 %j6};
//   &net8 @WIRE(mode="straight") {%j6 #M10:1};
//   &net2 @WIRE(mode="straight") {#M9:3 #M13:1};
//   &VSS @WIRE(mode="straight") {#M13:3 %gnd2::pin};
//   &net6 @WIRE(mode="straight") {#M10:3 #M14:1};
//   &VSS @WIRE(mode="straight") {#M14:3 %gnd3::pin};
//   &net5 @WIRE(mode="straight") {#M12:2 %j5};
//   &net5 @WIRE(mode="straight") {%j5 #M13:2};
//   &net5 @WIRE(mode="straight") {%j4 (17, -16) %j5};
//   &net8 @WIRE(mode="straight") {#M14:2 %j7};
//   &net8 @WIRE(mode="straight") {%j7 #M15:2};
//   &net8 @WIRE(mode="straight") {%j6 (45, -16) %j7};
//   &VB4 @WIRE(mode="straight") {#M9:2 #M10:2} => %wire2;
//   &VB4 @WIRE(mode="straight") {%port1::pin #M8:2};
//   &VB4 @WIRE(mode="straight") {#M11:2 %j8} => %wire3;
//   &VB1 @WIRE(mode="straight") {#M6:2 %j9} => %wire4;
//   &VP @WIRE(mode="straight") {#M5:2 %j10} => %wire5;
//   &VB1 @WIRE(mode="straight") {%port3::pin #M7:2};
//   &VB2 @WIRE(mode="straight") {%port2::pin #M1:2};
//   &INP @WIRE(mode="straight") {%port4::pin #M2:2};
//   &INN @WIRE(mode="straight") {%port5::pin #M3:2};
//   &OUT @WIRE(mode="straight") {%j11 %port6::pin};
//   $JUNCTION @ATTACH (25, 0)(p) => @PLACE(25, 0) => %dot1;
//   $JUNCTION @ATTACH %j1(p) => @PLACE(29, 0) => %dot2;
//   $JUNCTION @ATTACH %j11(p) => @PLACE(51, -15) => %dot3;
//   $JUNCTION @ATTACH %j2(p) => @PLACE(11, -15) => %dot4;
//   $JUNCTION @ATTACH %j5(p) => @PLACE(17, -26) => %dot5;
//   $JUNCTION @ATTACH %j4(p) => @PLACE(23, -16) => %dot6;
//   $JUNCTION @ATTACH %j3(p) => @PLACE(29, -10) => %dot7;
//   $JUNCTION @ATTACH %j6(p) => @PLACE(39, -16) => %dot8;
//   $JUNCTION @ATTACH %j7(p) => @PLACE(45, -26) => %dot9;
//   #M1
//       @TEXT("\textbf{\textit{M}}_{\textbf{1}}", key="name", dx=0.4, dy=-0.5, halign="start", valign="baseline", size=1.5116,
//       bold=false, textvisible=true);
//   $CANVAS_LABEL @ATTACH(bind="name") #M1::name(label);
//   #M2
//       @TEXT("\textbf{\textit{M}}_{\textbf{2}}", key="name", dx=0.4, dy=-0.5, halign="start", valign="baseline", size=1.5116,
//       bold=false, textvisible=true);
//   $CANVAS_LABEL @ATTACH(bind="name") #M2::name(label);
//   #M3
//       @TEXT("\textbf{\textit{M}}_{\textbf{3}}", key="name", dx=-0.4, dy=-0.5, halign="end", valign="baseline", size=1.5116,
//       bold=false, textvisible=true);
//   $CANVAS_LABEL @ATTACH(bind="name") #M3::name(label);
//   #M4
//       @TEXT("\textbf{\textit{M}}_{\textbf{4}}", key="name", dx=0.4, dy=-0.5, halign="start", valign="baseline", size=1.5116,
//       bold=false, textvisible=true);
//   $CANVAS_LABEL @ATTACH(bind="name") #M4::name(label);
//   #M6
//       @TEXT("\textbf{\textit{M}}_{\textbf{6}}", key="name", dx=-0.4, dy=-0.5, halign="end", valign="baseline", size=1.5116,
//       bold=false, textvisible=true);
//   $CANVAS_LABEL @ATTACH(bind="name") #M6::name(label);
//   #M5
//       @TEXT("\textbf{\textit{M}}_{\textbf{5}}", key="name", dx=-0.4, dy=-0.5, halign="end", valign="baseline", size=1.5116,
//       bold=false, textvisible=true);
//   $CANVAS_LABEL @ATTACH(bind="name") #M5::name(label);
//   #M7
//       @TEXT("\textbf{\textit{M}}_{\textbf{7}}", key="name", dx=-0.4, dy=-0.5, halign="end", valign="baseline", size=1.5116,
//       bold=false, textvisible=true);
//   $CANVAS_LABEL @ATTACH(bind="name") #M7::name(label);
//   #M8
//       @TEXT("\textbf{\textit{M}}_{\textbf{8}}", key="name", dx=0.5, dy=-0.5, halign="start", valign="baseline", size=1.5116,
//       bold=false, textvisible=true);
//   $CANVAS_LABEL @ATTACH(bind="name") #M8::name(label);
//   #M12
//       @TEXT("\textbf{\textit{M}}_{\textbf{12}}", key="name", dx=-0.5, dy=-0.5, halign="end", valign="baseline", size=1.5116,
//       bold=false, textvisible=true);
//   $CANVAS_LABEL @ATTACH(bind="name") #M12::name(label);
//   #M9
//       @TEXT("\textbf{\textit{M}}_{\textbf{9}}", key="name", dx=-0.5, dy=-0.5, halign="end", valign="baseline", size=1.5116,
//       bold=false, textvisible=true);
//   $CANVAS_LABEL @ATTACH(bind="name") #M9::name(label);
//   #M13
//       @TEXT("\textbf{\textit{M}}_{\textbf{13}}", key="name", dx=0.5, dy=-0.5, halign="start", valign="baseline", size=1.5116,
//       bold=false, textvisible=true);
//   $CANVAS_LABEL @ATTACH(bind="name") #M13::name(label);
//   #M10
//       @TEXT("\textbf{\textit{M}}_{\textbf{10}}", key="name", dx=0.5, dy=-0.5, halign="start", valign="baseline", size=1.5116,
//       bold=false, textvisible=true);
//   $CANVAS_LABEL @ATTACH(bind="name") #M10::name(label);
//   #M14
//       @TEXT("\textbf{\textit{M}}_{\textbf{14}}", key="name", dx=-0.5, dy=-0.5, halign="end", valign="baseline", size=1.5116,
//       bold=false, textvisible=true);
//   $CANVAS_LABEL @ATTACH(bind="name") #M14::name(label);
//   #M11
//       @TEXT("\textbf{\textit{M}}_{\textbf{11}}", key="name", dx=-0.5, dy=-0.5, halign="end", valign="baseline", size=1.5116,
//       bold=false, textvisible=true);
//   $CANVAS_LABEL @ATTACH(bind="name") #M11::name(label);
//   #M15
//       @TEXT("\textbf{\textit{M}}_{\textbf{15}}", key="name", dx=0.5, dy=-0.5, halign="start", valign="baseline", size=1.5116,
//       bold=false, textvisible=true);
//   $CANVAS_LABEL @ATTACH(bind="name") #M15::name(label);
//   %vdd1 @TEXT("\textbf{\textit{V}}_{\textbf{DD}}", dx=2, dy=1, size=1.5116, bold=false) => %power1;
//   $CANVAS_LABEL @ATTACH(bind="port") %power1(label);
//   %port1
//       @TEXT("\textbf{\textit{V}}_{\textbf{B4}}", key="netname", dx=-2, dy=-0.5, halign="end", valign="baseline", size=1.5116,
//       bold=false, textvisible=true);
//   $CANVAS_LABEL @ATTACH(bind="port") %port1::netname(label);
//   %port2
//       @TEXT("\textbf{\textit{V}}_{\textbf{B2}}", key="netname", dx=-2, dy=-0.5, halign="end", valign="baseline", size=1.5116,
//       bold=false, textvisible=true);
//   $CANVAS_LABEL @ATTACH(bind="port") %port2::netname(label);
//   %port3
//       @TEXT("\textbf{\textit{V}}_{\textbf{B1}}", key="netname", dx=2, dy=-0.5, halign="start", valign="baseline", size=1.5116,
//       bold=false, textvisible=true);
//   $CANVAS_LABEL @ATTACH(bind="port") %port3::netname(label);
//   %port4
//       @TEXT("\textbf{\textit{INP}}", key="netname", dx=-0.5, dy=1.2, halign="middle", valign="baseline", size=1.5116, bold=false,
//       textvisible=true);
//   $CANVAS_LABEL @ATTACH(bind="port") %port4::netname(label);
//   %port5
//       @TEXT("\textbf{\textit{INN}}", key="netname", dx=2, dy=-0.5, halign="start", valign="baseline", size=1.5116, bold=false,
//       textvisible=true);
//   $CANVAS_LABEL @ATTACH(bind="port") %port5::netname(label);
//   %port6
//       @TEXT("\textbf{\textit{OUT}}", key="netname", dx=2, dy=-0.5, halign="start", valign="baseline", size=1.5116, bold=false,
//       textvisible=true);
//   $CANVAS_LABEL @ATTACH(bind="port") %port6::netname(label);
//   %wire2 @TEXT("\textbf{\textit{V}}_{\textbf{B4}}", halign="middle", size=1.5116, bold=false) => @PLACE(31, -19) => %label1;
//   $CANVAS_LABEL @ATTACH(bind="net") %label1(label);
//   %wire3 @TEXT("\textbf{\textit{V}}_{\textbf{B4}}", halign="middle", size=1.5116, bold=false) => @PLACE(56, -19) => %label2;
//   $CANVAS_LABEL @ATTACH(bind="net") %label2(label);
//   %wire4 @TEXT("\textbf{\textit{V}}_{\textbf{B1}}", halign="middle", size=1.5116, bold=false) => @PLACE(16, -9) => %label3;
//   $CANVAS_LABEL @ATTACH(bind="net") %label3(label);
//   %wire5 @TEXT("\textbf{\textit{V}}_{\textbf{P}}", halign="middle", size=1.5116, bold=false) => @PLACE(56, -3) => %label4;
//   $CANVAS_LABEL @ATTACH(bind="net") %label4(label);
//   %wire1 @TEXT("\textbf{\textit{V}}_{\textbf{P}}", size=1.5116, bold=false) => @PLACE(7.8, -8) => %label5;
//   $CANVAS_LABEL @ATTACH(bind="net") %label5(label);
//   %vdd1 @TEXT("${p}", key="netname", textvisible=false)
// }
ends opamp

subckt dut (VDD VSS Vout VB3 VB1 VB2)
M16 (VB4 net1 VDD VDD) sky130_fd_pr__pfet_01v8 l=0.15 w=1 nf=1 m=1
M17 (VB4 VB4 VZ VSS) sky130_fd_pr__nfet_01v8 l=0.15 w=1 nf=1 m=1
M18 (VZ VB4 VSS VSS) sky130_fd_pr__nfet_01v8 l=0.15 w=1 nf=1 m=1
M19 (net1 net1 VDD VDD) sky130_fd_pr__pfet_01v8 l=0.15 w=1 nf=1 m=1
M20 (net1 net0 VB3 VSS) sky130_fd_pr__nfet_01v8 l=0.15 w=1 nf=1 m=1
M21 (net0 net1 VDD VDD) sky130_fd_pr__pfet_01v8 l=0.15 w=1 nf=1 m=1
M22 (net0 VB3 VSS VSS) sky130_fd_pr__nfet_01v8 l=0.15 w=1 nf=1 m=1
Q1 (X X VSS VSS) sky130_fd_pr__npn_05v5_W1p00L1p00 m=1
Q2 (VZ VZ VSS VSS) sky130_fd_pr__npn_05v5_W1p00L1p00 m=1
R1 (Vout X) resistor r=1k
R2 (Vout Y) resistor r=1k
R3 (Y VZ) resistor r=1k
R4 (VB3 VSS) resistor r=1k
X1 (VDD VSS VB4 VB2 VB1 X Y Vout) opamp
// @RNL(author="analog-canvas") {
//   %dut_SYMBOL = @DEFINE-SYMBOL(box=[-6, -5, 6, 5]) {
//     (0, 5) @PIN(terminal="VDD", label="\textbf{\textit{V}}_{\textbf{DD}}", direction="up");
//     (6, 0) @PIN(terminal="Vout", label="\textbf{\textit{V}}_{\textbf{out}}", direction="right");
//     (6, -2) @PIN(terminal="VB3", label="\textbf{\textit{V}}_{\textbf{B3}}", direction="right");
//     (-6, 0) @PIN(terminal="VB1", label="\textbf{\textit{V}}_{\textbf{B1}}", direction="left");
//     (-6, -2) @PIN(terminal="VB2", label="\textbf{\textit{V}}_{\textbf{B2}}", direction="left");
//     (0, 0) @RECTANGLE(width=10, height=8);
//     @LINE {(0, 5) (0, 4)};
//     @LINE {(6, 0) (5, 0)};
//     @LINE {(6, -2) (5, -2)};
//     @LINE {(-6, 0) (-5, 0)};
//     @LINE {(-6, -2) (-5, -2)}
//   };
//   # @SET-SYMBOL %dut_SYMBOL;
//   $CANVAS_TYPESETTING @ATTACH(subscript_italic=false) #(level);
//   #X1 @PLACE(44, -17) => @ORIENT("R0");
//   #R1 @SET-SYMBOL $RESISTOR => @PLACE(10, -10) => @ORIENT("R0");
//   #R2 @SET-SYMBOL $RESISTOR => @PLACE(26, -10) => @ORIENT("R0");
//   #R3 @SET-SYMBOL $RESISTOR => @PLACE(26, -23) => @ORIENT("R0");
//   #Q1 @SET-SYMBOL(terminals=[[1, "c"], [2, "b"], [3, "e"]]) $NPN => @PLACE(10, -33) => @ORIENT("R0");
//   #Q2 @SET-SYMBOL(terminals=[[1, "c"], [2, "b"], [3, "e"]]) $NPN => @PLACE(26, -33) => @ORIENT("R0");
//   $GROUND @ATTACH &VSS(p) => @SET-SYMBOL $GROUND_SYMBOL => @PLACE(10, -36) => @ORIENT("R0") => %gnd1;
//   $GROUND @ATTACH &VSS(p) => @SET-SYMBOL $GROUND_SYMBOL => @PLACE(26, -36) => @ORIENT("R0") => %gnd2;
//   $SUPPLY @ATTACH &VDD(p) => @SET-SYMBOL $SUPPLY_SYMBOL => @PLACE(44, -8) => @ORIENT("R0") => %vdd1;
//   $IO_PORT @ATTACH &Vout(p) => @SET-SYMBOL $IO_PORT_SYMBOL => @PLACE(64, -17) => @ORIENT("MY") => %port1;
//   #M16 @SET-SYMBOL(terminals=[[1, "d"], [2, "g"], [3, "s"]]) $PMOS => @PLACE(71, -32) => @ORIENT("MY");
//   #M19 @SET-SYMBOL(terminals=[[1, "d"], [2, "g"], [3, "s"]]) $PMOS => @PLACE(81, -32) => @ORIENT("R0");
//   #M21 @SET-SYMBOL(terminals=[[1, "d"], [2, "g"], [3, "s"]]) $PMOS => @PLACE(91, -32) => @ORIENT("R0");
//   #M17 @SET-SYMBOL(terminals=[[1, "d"], [2, "g"], [3, "s"]]) $NMOS => @PLACE(71, -40) => @ORIENT("MY");
//   #M18 @SET-SYMBOL(terminals=[[1, "d"], [2, "g"], [3, "s"]]) $NMOS => @PLACE(71, -48) => @ORIENT("MY");
//   #M20 @SET-SYMBOL(terminals=[[1, "d"], [2, "g"], [3, "s"]]) $NMOS => @PLACE(81, -40) => @ORIENT("MY");
//   #M22 @SET-SYMBOL(terminals=[[1, "d"], [2, "g"], [3, "s"]]) $NMOS => @PLACE(91, -40) => @ORIENT("MY");
//   #R4 @SET-SYMBOL $RESISTOR => @PLACE(81, -46) => @ORIENT("R0");
//   $SUPPLY @ATTACH &VDD(p) => @SET-SYMBOL $SUPPLY_SYMBOL => @PLACE(76, -28) => @ORIENT("R0") => %vdd2;
//   $GROUND @ATTACH &VSS(p) => @SET-SYMBOL $GROUND_SYMBOL => @PLACE(81, -49) => @ORIENT("R0") => %gnd3;
//   $GROUND @ATTACH &VSS(p) => @SET-SYMBOL $GROUND_SYMBOL => @PLACE(91, -44) => @ORIENT("R0") => %gnd4;
//   $GROUND @ATTACH &VSS(p) => @SET-SYMBOL $GROUND_SYMBOL => @PLACE(71, -52) => @ORIENT("R0") => %gnd5;
//   $IO_PORT @ATTACH &VB3(p) => @SET-SYMBOL $IO_PORT_SYMBOL => @PLACE(97, -40) => @ORIENT("MY") => %port2;
//   $IO_PORT @ATTACH &VB1(p) => @SET-SYMBOL $IO_PORT_SYMBOL => @PLACE(37, -29) => @ORIENT("R0") => %port3;
//   $IO_PORT @ATTACH &VB2(p) => @SET-SYMBOL $IO_PORT_SYMBOL => @PLACE(37, -32) => @ORIENT("R0") => %port4;
//   %j1 = (56, -17);
//   %j2 = (26, -2);
//   %j3 = (26, -15);
//   %j4 = (10, -19);
//   %j5 = (10, -29);
//   %j6 = (26, -29);
//   %j7 = (47, -27);
//   %j8 = (81, -28);
//   %j9 = (76, -32);
//   %j10 = (81, -35);
//   %j11 = (81, -36);
//   %j12 = (91, -37);
//   %j13 = (71, -37);
//   %j14 = (75, -39);
//   %j15 = (75, -40);
//   &Vout @WIRE(mode="straight") {#X1:8 %j1};
//   &Vout @WIRE(mode="straight") {%j1 %port1::pin};
//   &Vout @WIRE(mode="straight") {#R1:1 (10, -2) %j2};
//   &Vout @WIRE(mode="straight") {%j2 (56, -2) %j1};
//   &Vout @WIRE(mode="straight") {#R2:1 %j2};
//   &X @WIRE(mode="straight") {#R1:2 %j4} => %wire1;
//   &X @WIRE(mode="straight") {%j4 %j5};
//   &X @WIRE(mode="straight") {%j5 #Q1:1};
//   &Y @WIRE(mode="straight") {#R2:2 %j3} => %wire2;
//   &Y @WIRE(mode="straight") {%j3 #R3:1};
//   &Y @WIRE(mode="straight") {%j3 #X1:7};
//   &X @WIRE(mode="straight") {%j4 #X1:6};
//   &VZ @WIRE(mode="straight") {#R3:2 %j6};
//   &VZ @WIRE(mode="straight") {%j6 #Q2:1} => %wire3;
//   &X @WIRE(mode="straight") {#Q1:2 (6, -33) (6, -29) %j5};
//   &VZ @WIRE(mode="straight") {#Q2:2 (22, -33) (22, -29) %j6};
//   &VSS @WIRE(mode="straight") {#Q1:3 %gnd1::pin};
//   &VSS @WIRE(mode="straight") {#Q2:3 %gnd2::pin};
//   &VB4 @WIRE(mode="straight") {#X1:3 %j7} => %wire4;
//   &VDD @WIRE(mode="straight") {#X1:1 %vdd1::pin};
//   &VDD @WIRE(mode="straight") {%vdd2::pin (71, -28) #M16:3};
//   &VDD @WIRE(mode="straight") {%vdd2::pin %j8};
//   &VDD @WIRE(mode="straight") {%j8 (91, -28) #M21:3};
//   &VDD @WIRE(mode="straight") {#M19:3 %j8};
//   &net1 @WIRE(mode="straight") {#M16:2 %j9};
//   &net1 @WIRE(mode="straight") {%j9 #M19:2};
//   &net1 @WIRE(mode="straight") {#M19:1 %j10};
//   &net1 @WIRE(mode="straight") {%j10 %j11};
//   &net1 @WIRE(mode="straight") {%j11 #M20:1};
//   &net1 @WIRE(mode="straight") {%j9 (76, -35) %j10};
//   &net1 @WIRE(mode="straight") {#M21:2 (86, -32) (86, -36) %j11};
//   &net0 @WIRE(mode="straight") {#M21:1 %j12};
//   &net0 @WIRE(mode="straight") {%j12 #M22:1};
//   &net0 @WIRE(mode="straight") {#M20:2 (88, -40) (88, -37) %j12};
//   &VB3 @WIRE(mode="straight") {#M20:3 #R4:1} => %wire5;
//   &VSS @WIRE(mode="straight") {#R4:2 %gnd3::pin};
//   &VSS @WIRE(mode="straight") {#M22:3 %gnd4::pin};
//   &VB3 @WIRE(mode="straight") {%port2::pin #M22:2};
//   &VZ @WIRE(mode="straight") {#M17:3 #M18:1} => %wire6;
//   &VSS @WIRE(mode="straight") {#M18:3 %gnd5::pin};
//   &VB4 @WIRE(mode="straight") {#M16:1 %j13} => %wire7;
//   &VB4 @WIRE(mode="straight") {%j13 #M17:1};
//   &VB4 @WIRE(mode="straight") {%j13 (75, -37) %j14};
//   &VB4 @WIRE(mode="straight") {#M17:2 %j15};
//   &VB4 @WIRE(mode="straight") {#M18:2 (75, -48) %j15};
//   &VB4 @WIRE(mode="straight") {%j14 %j15};
//   &VB1 @WIRE(mode="straight") {%port3::pin (41, -29) #X1:5};
//   &VB2 @WIRE(mode="straight") {%port4::pin (44, -32) #X1:4};
//   $JUNCTION @ATTACH (76, -28)(p) => @PLACE(76, -28) => %dot1;
//   $JUNCTION @ATTACH %j8(p) => @PLACE(81, -28) => %dot2;
//   $JUNCTION @ATTACH %j2(p) => @PLACE(26, -2) => %dot3;
//   $JUNCTION @ATTACH %j1(p) => @PLACE(56, -17) => %dot4;
//   $JUNCTION @ATTACH %j6(p) => @PLACE(26, -29) => %dot5;
//   $JUNCTION @ATTACH %j13(p) => @PLACE(71, -37) => %dot6;
//   $JUNCTION @ATTACH %j15(p) => @PLACE(75, -40) => %dot7;
//   $JUNCTION @ATTACH %j12(p) => @PLACE(91, -37) => %dot8;
//   $JUNCTION @ATTACH %j9(p) => @PLACE(76, -32) => %dot9;
//   $JUNCTION @ATTACH %j10(p) => @PLACE(81, -35) => %dot10;
//   $JUNCTION @ATTACH %j11(p) => @PLACE(81, -36) => %dot11;
//   $JUNCTION @ATTACH %j4(p) => @PLACE(10, -19) => %dot12;
//   $JUNCTION @ATTACH %j5(p) => @PLACE(10, -29) => %dot13;
//   $JUNCTION @ATTACH %j3(p) => @PLACE(26, -15) => %dot14;
//   #R1
//       @TEXT("\textbf{\textit{R}}_{\textbf{1}}", key="name", dx=0.9, dy=-0.5, halign="start", valign="baseline", size=1.5116,
//       bold=false, textvisible=true);
//   $CANVAS_LABEL @ATTACH(bind="name") #R1::name(label);
//   #R2
//       @TEXT("\textbf{\textit{R}}_{\textbf{2}}", key="name", dx=0.9, dy=-0.5, halign="start", valign="baseline", size=1.5116,
//       bold=false, textvisible=true);
//   $CANVAS_LABEL @ATTACH(bind="name") #R2::name(label);
//   #R3
//       @TEXT("\textbf{\textit{R}}_{\textbf{3}}", key="name", dx=0.9, dy=-0.5, halign="start", valign="baseline", size=1.5116,
//       bold=false, textvisible=true);
//   $CANVAS_LABEL @ATTACH(bind="name") #R3::name(label);
//   #Q1
//       @TEXT("\textbf{\textit{Q}}_{\textbf{1}}", key="name", dx=0.4, dy=-0.5, halign="start", valign="baseline", size=1.5116,
//       bold=false, textvisible=true);
//   $CANVAS_LABEL @ATTACH(bind="name") #Q1::name(label);
//   #Q2
//       @TEXT("\textbf{\textit{Q}}_{\textbf{2}}", key="name", dx=0.4, dy=-0.5, halign="start", valign="baseline", size=1.5116,
//       bold=false, textvisible=true);
//   $CANVAS_LABEL @ATTACH(bind="name") #Q2::name(label);
//   %vdd1 @TEXT("\textbf{\textit{V}}_{\textbf{DD}}", dx=2, dy=1, size=1.5116, bold=false) => %power1;
//   $CANVAS_LABEL @ATTACH(bind="port") %power1(label);
//   %port1
//       @TEXT("\textbf{\textit{V}}_{\textbf{out}}", key="netname", dx=2, dy=-0.5, halign="start", valign="baseline", size=1.5116,
//       bold=false, textvisible=true);
//   $CANVAS_LABEL @ATTACH(bind="port") %port1::netname(label);
//   #M16
//       @TEXT("\textbf{\textit{M}}_{\textbf{16}}", key="name", dx=-0.4, dy=-0.5, halign="end", valign="baseline", size=1.5116,
//       bold=false, textvisible=true);
//   $CANVAS_LABEL @ATTACH(bind="name") #M16::name(label);
//   #M19
//       @TEXT("\textbf{\textit{M}}_{\textbf{19}}", key="name", dx=0.4, dy=-0.5, halign="start", valign="baseline", size=1.5116,
//       bold=false, textvisible=true);
//   $CANVAS_LABEL @ATTACH(bind="name") #M19::name(label);
//   #M21
//       @TEXT("\textbf{\textit{M}}_{\textbf{21}}", key="name", dx=0.4, dy=-0.5, halign="start", valign="baseline", size=1.5116,
//       bold=false, textvisible=true);
//   $CANVAS_LABEL @ATTACH(bind="name") #M21::name(label);
//   #M17
//       @TEXT("\textbf{\textit{M}}_{\textbf{17}}", key="name", dx=-0.5, dy=-0.5, halign="end", valign="baseline", size=1.5116,
//       bold=false, textvisible=true);
//   $CANVAS_LABEL @ATTACH(bind="name") #M17::name(label);
//   #M18
//       @TEXT("\textbf{\textit{M}}_{\textbf{18}}", key="name", dx=-0.5, dy=-0.5, halign="end", valign="baseline", size=1.5116,
//       bold=false, textvisible=true);
//   $CANVAS_LABEL @ATTACH(bind="name") #M18::name(label);
//   #M20
//       @TEXT("\textbf{\textit{M}}_{\textbf{20}}", key="name", dx=-0.5, dy=-0.5, halign="end", valign="baseline", size=1.5116,
//       bold=false, textvisible=true);
//   $CANVAS_LABEL @ATTACH(bind="name") #M20::name(label);
//   #M22
//       @TEXT("\textbf{\textit{M}}_{\textbf{22}}", key="name", dx=-0.5, dy=-0.5, halign="end", valign="baseline", size=1.5116,
//       bold=false, textvisible=true);
//   $CANVAS_LABEL @ATTACH(bind="name") #M22::name(label);
//   #R4
//       @TEXT("\textbf{\textit{R}}_{\textbf{4}}", key="name", dx=0.9, dy=-0.5, halign="start", valign="baseline", size=1.5116,
//       bold=false, textvisible=true);
//   $CANVAS_LABEL @ATTACH(bind="name") #R4::name(label);
//   %vdd2 @TEXT("\textbf{\textit{V}}_{\textbf{DD}}", dx=2, dy=1, size=1.5116, bold=false) => %power2;
//   $CANVAS_LABEL @ATTACH(bind="port") %power2(label);
//   %port2
//       @TEXT("\textbf{\textit{V}}_{\textbf{B3}}", key="netname", dx=2, dy=-0.5, halign="start", valign="baseline", size=1.5116,
//       bold=false, textvisible=true);
//   $CANVAS_LABEL @ATTACH(bind="port") %port2::netname(label);
//   %wire3 @TEXT("\textbf{\textit{V}}_{\textbf{Z}}", size=1.5116, bold=false) => @PLACE(26.8, -30) => %label1;
//   $CANVAS_LABEL @ATTACH(bind="net") %label1(label);
//   %wire6 @TEXT("\textbf{\textit{V}}_{\textbf{Z}}", size=1.5116, bold=false) => @PLACE(71.8, -44) => %label2;
//   $CANVAS_LABEL @ATTACH(bind="net") %label2(label);
//   %wire7 @TEXT("\textbf{\textit{V}}_{\textbf{B4}}", size=1.5116, bold=false) => @PLACE(71.8, -35.5) => %label3;
//   $CANVAS_LABEL @ATTACH(bind="net") %label3(label);
//   %wire4 @TEXT("\textbf{\textit{V}}_{\textbf{B4}}", size=1.5116, bold=false) => @PLACE(47.8, -27) => %label4;
//   $CANVAS_LABEL @ATTACH(bind="net") %label4(label);
//   %wire5 @TEXT("\textbf{\textit{V}}_{\textbf{B3}}", size=1.5116, bold=false) => @PLACE(81.8, -43) => %label5;
//   $CANVAS_LABEL @ATTACH(bind="net") %label5(label);
//   %wire1 @TEXT("\textbf{\textit{X}}", size=1.5116, bold=false) => @PLACE(10.8, -19) => %label6;
//   $CANVAS_LABEL @ATTACH(bind="net") %label6(label);
//   %wire2 @TEXT("\textbf{\textit{Y}}", size=1.5116, bold=false) => @PLACE(26.8, -15) => %label7;
//   $CANVAS_LABEL @ATTACH(bind="net") %label7(label);
//   #X1
//       @TEXT("\textbf{\textit{A}}_{\textbf{1}}", key="name", dx=-1, dy=-0.2, halign="middle", valign="baseline", size=1.5116,
//       bold=false, textvisible=true);
//   %port3
//       @TEXT("\textbf{\textit{V}}_{\textbf{B1}}", key="netname", dx=-2, dy=-0.5, halign="end", valign="baseline", size=1.5116,
//       bold=false, textvisible=true);
//   $CANVAS_LABEL @ATTACH(bind="port") %port3::netname(label);
//   %port4
//       @TEXT("\textbf{\textit{V}}_{\textbf{B2}}", key="netname", dx=-2, dy=-0.5, halign="end", valign="baseline", size=1.5116,
//       bold=false, textvisible=true);
//   $CANVAS_LABEL @ATTACH(bind="port") %port4::netname(label);
//   (33.2, -23.2) @TEXT("V\_T \textbackslash{}ln n", halign="middle", size=1.5116, bold=true) => %text1;
//   $CANVAS_TYPOGRAPHY @ATTACH(token="label") %text1(text);
//   (13.2, -33.5) @TEXT("A", halign="middle", size=1.5116, bold=true) => %text2;
//   $CANVAS_TYPOGRAPHY @ATTACH(token="label") %text2(text);
//   (29.5, -33.5) @TEXT("nA", halign="middle", size=1.5116, bold=true) => %text3;
//   $CANVAS_TYPOGRAPHY @ATTACH(token="label") %text3(text);
//   %vdd1 @TEXT("${p}", key="netname", textvisible=false);
//   %vdd2 @TEXT("${p}", key="netname", textvisible=false)
// }
ends dut
