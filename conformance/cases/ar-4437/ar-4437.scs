simulator lang=spectre
// @RNL(type="header") {
//   @VERSION("0.4");
//   @USE-PACKAGE(name="rnl-std-style", version="0.4");
//   @USE-PACKAGE(name="rnl-std-basic", version="0.4");
//   @USE-PACKAGE(name="rnl-std-semiconductors", version="0.4");
//   @USE-PACKAGE(name="rnl-std-no-labels", version="0.4");
//   @USE-PACKAGE(name="analog-canvas-extensions", version="0.7")
// }

subckt dut (VDD VSS VG)
model DIODE diode is=1e-14 n=1
D1 (net2 net0) DIODE
Ii (VSS net3) isource dc=1m
M1 (net1 VG net3 VSS) sky130_fd_pr__nfet_01v8 l=0.15 w=1 nf=1 m=1
M2 (net2 net1 VDD VDD) sky130_fd_pr__pfet_01v8 l=0.15 w=1 nf=1 m=1
RD1 (VDD net1) resistor r=525
RD2 (net0 VSS) resistor r=250
RF (net3 net0) resistor r=500
// @RNL(author="analog-canvas") {
//   %dut_SYMBOL = @DEFINE-SYMBOL(box=[-5, -4, 5, 4]) {
//     (0, 4) @PIN(terminal="VDD", label="\textbf{\textit{V}}_{\textbf{DD}}", direction="up");
//     (-5, -1) @PIN(terminal="VG", label="\textbf{\textit{V}}_{\textbf{G}}", direction="left");
//     (0, 0) @RECTANGLE(width=8, height=6);
//     @LINE {(0, 4) (0, 3)};
//     @LINE {(-5, -1) (-4, -1)}
//   };
//   # @SET-SYMBOL %dut_SYMBOL;
//   $CANVAS_TYPESETTING @ATTACH(subscript_italic=false) #(level);
//   #Ii @SET-SYMBOL $CURRENT_SOURCE => @PLACE(16, -24) => @ORIENT("R180");
//   $CANVAS_PARAMETER @ATTACH(name="amplitude", text="1m") #Ii(part);
//   $CANVAS_PARAMETER @ATTACH(name="damping", text="0") #Ii(part);
//   $CANVAS_PARAMETER @ATTACH(name="delay", text="0") #Ii(part);
//   $CANVAS_PARAMETER @ATTACH(name="fall", text="1ps") #Ii(part);
//   $CANVAS_PARAMETER @ATTACH(name="frequency", text="1k") #Ii(part);
//   $CANVAS_PARAMETER @ATTACH(name="high", text="1m") #Ii(part);
//   $CANVAS_PARAMETER @ATTACH(name="low", text="0") #Ii(part);
//   $CANVAS_PARAMETER @ATTACH(name="offset", text="0") #Ii(part);
//   $CANVAS_PARAMETER @ATTACH(name="period", text="10ns") #Ii(part);
//   $CANVAS_PARAMETER @ATTACH(name="phase", text="0") #Ii(part);
//   $CANVAS_PARAMETER @ATTACH(name="rise", text="1ps") #Ii(part);
//   $CANVAS_PARAMETER @ATTACH(name="waveform", text="dc") #Ii(part);
//   $CANVAS_PARAMETER @ATTACH(name="width", text="5ns") #Ii(part);
//   #M1 @SET-SYMBOL(terminals=[[1, "d"], [2, "g"], [3, "s"]]) $NMOS => @PLACE(26, -20) => @ORIENT("MXR90");
//   #RD1 @SET-SYMBOL $RESISTOR => @PLACE(31, -16) => @ORIENT("R0");
//   $CANVAS_PARAMETER_TEXT @ATTACH(name="r", text="525Ω") #RD1(part);
//   #M2 @SET-SYMBOL(terminals=[[1, "d"], [2, "g"], [3, "s"]]) $PMOS => @PLACE(39, -20) => @ORIENT("R0");
//   #D1 @SET-SYMBOL(terminals=[[1, "a"], [2, "k"]]) $LED => @PLACE(39, -25) => @ORIENT("R270");
//   #RD2 @SET-SYMBOL $RESISTOR => @PLACE(39, -30) => @ORIENT("R0");
//   $CANVAS_PARAMETER_TEXT @ATTACH(name="r", text="250Ω") #RD2(part);
//   #RF @SET-SYMBOL $RESISTOR => @PLACE(30, -28) => @ORIENT("R90");
//   $CANVAS_PARAMETER_TEXT @ATTACH(name="r", text="500Ω") #RF(part);
//   $SUPPLY @ATTACH &VDD(p) => @SET-SYMBOL $SUPPLY_SYMBOL => @PLACE(35, -12) => @ORIENT("R0") => %vdd1;
//   $GROUND @ATTACH &VSS(p) => @SET-SYMBOL $GROUND_SYMBOL => @PLACE(16, -26) => @ORIENT("R0") => %gnd1;
//   $GROUND @ATTACH &VSS(p) => @SET-SYMBOL $GROUND_SYMBOL => @PLACE(39, -32) => @ORIENT("R0") => %gnd2;
//   $IO_PORT @ATTACH &VG(p) => @SET-SYMBOL $IO_PORT_SYMBOL => @PLACE(26, -25) => @ORIENT("R90") => %port1;
//   %j1 = (31, -20);
//   %j2 = (20, -20);
//   &VDD @WIRE(mode="straight") {#RD1:1 (31, -12) %vdd1::pin};
//   &VDD @WIRE(mode="straight") {#M2:3 (39, -12) %vdd1::pin};
//   &net1 @WIRE(mode="straight") {#M1:1 %j1};
//   &net1 @WIRE(mode="straight") {%j1 #M2:2};
//   &net1 @WIRE(mode="straight") {#RD1:2 %j1};
//   &net3 @WIRE(mode="straight") {#Ii:2 (16, -20) %j2};
//   &net3 @WIRE(mode="straight") {%j2 #M1:3};
//   &VG @WIRE(mode="straight") {%port1::pin #M1:2};
//   &net2 @WIRE(mode="straight") {#M2:1 #D1:1};
//   &net0 @WIRE(mode="straight") {#D1:2 #RD2:1};
//   &net0 @WIRE(mode="straight") {#RF:2 #RD2:1};
//   &net3 @WIRE(mode="straight") {#RF:1 (20, -28) %j2};
//   $JUNCTION @ATTACH (35, -12)(p) => @PLACE(35, -12) => %dot1;
//   &VSS @WIRE(mode="straight") {%gnd1::pin #Ii:1};
//   &VSS @WIRE(mode="straight") {%gnd2::pin #RD2:2};
//   $JUNCTION @ATTACH (39, -28)(p) => @PLACE(39, -28) => %dot2;
//   $JUNCTION @ATTACH %j1(p) => @PLACE(31, -20) => %dot3;
//   $JUNCTION @ATTACH %j2(p) => @PLACE(20, -20) => %dot4;
//   #Ii
//       @TEXT("\textbf{\textit{I}}_{\textbf{i}}", key="name", dx=-1.5, dy=-0.5, halign="end", valign="baseline", size=1.5116,
//       bold=false, textvisible=true);
//   $CANVAS_LABEL @ATTACH(bind="name") #Ii::name(label);
//   #M1
//       @TEXT("\textbf{\textit{M}}_{\textbf{1}}", key="name", dx=0, dy=1, halign="middle", valign="baseline", size=1.5116,
//       bold=false, textvisible=true);
//   $CANVAS_LABEL @ATTACH(bind="name") #M1::name(label);
//   #RD1
//       @TEXT("\textbf{\textit{R}}_{\textbf{D1}}", key="name", dx=0.9, dy=0.9, halign="start", valign="baseline", size=1.5116,
//       bold=false, textvisible=true);
//   $CANVAS_LABEL @ATTACH(bind="name") #RD1::name(label);
//   #RD1
//       @TEXT("\textbf{525Ω}", key="value", dx=0.9, dy=-1.1, halign="start", valign="baseline", size=1.5116, bold=false,
//       textvisible=true);
//   $CANVAS_LABEL @ATTACH(bind="value") #RD1::value(label);
//   #M2
//       @TEXT("\textbf{\textit{M}}_{\textbf{2}}", key="name", dx=0.4, dy=-0.5, halign="start", valign="baseline", size=1.5116,
//       bold=false, textvisible=true);
//   $CANVAS_LABEL @ATTACH(bind="name") #M2::name(label);
//   #D1
//       @TEXT("\textbf{\textit{LED}}", key="name", dx=-1.1, dy=-0.5, halign="end", valign="baseline", size=1.5116, bold=false,
//       textvisible=true);
//   #RD2
//       @TEXT("\textbf{\textit{R}}_{\textbf{D2}}", key="name", dx=0.9, dy=-0.5, halign="start", valign="baseline", size=1.5116,
//       bold=false, textvisible=true);
//   $CANVAS_LABEL @ATTACH(bind="name") #RD2::name(label);
//   #RD2
//       @TEXT("\textbf{250Ω}", key="value", dx=0.9, dy=-2.5, halign="start", valign="baseline", size=1.5116, bold=false,
//       textvisible=true);
//   $CANVAS_LABEL @ATTACH(bind="value") #RD2::value(label);
//   #RF
//       @TEXT("\textbf{\textit{R}}_{\textbf{F}}", key="name", dx=0, dy=-2, halign="middle", valign="baseline", size=1.5116,
//       bold=false, textvisible=true);
//   $CANVAS_LABEL @ATTACH(bind="name") #RF::name(label);
//   #RF
//       @TEXT("\textbf{500Ω}", key="value", dx=0, dy=-4, halign="middle", valign="baseline", size=1.5116, bold=false,
//       textvisible=true);
//   $CANVAS_LABEL @ATTACH(bind="value") #RF::value(label);
//   %vdd1 @TEXT("\textbf{\textit{V}}_{\textbf{DD}}", dx=2, dy=1, size=1.5116, bold=false) => %power1;
//   $CANVAS_LABEL @ATTACH(bind="port") %power1(label);
//   %port1
//       @TEXT("\textbf{\textit{V}}_{\textbf{G}}", key="netname", dx=1.2, dy=-1, halign="start", valign="baseline", size=1.5116,
//       bold=false, textvisible=true);
//   $CANVAS_LABEL @ATTACH(bind="port") %port1::netname(label);
//   %vdd1 @TEXT("${p}", key="netname", textvisible=false)
// }
ends dut
