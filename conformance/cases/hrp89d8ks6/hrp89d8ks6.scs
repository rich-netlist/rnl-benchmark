simulator lang=spectre
// @RNL(type="header") {
//   @VERSION("0.4");
//   @USE-PACKAGE(name="rnl-std-style", version="0.4");
//   @USE-PACKAGE(name="rnl-std-basic", version="0.4");
//   @USE-PACKAGE(name="rnl-std-semiconductors", version="0.4");
//   @USE-PACKAGE(name="rnl-std-no-labels", version="0.4");
//   @USE-PACKAGE(name="analog-canvas-extensions", version="0.7");
//   @USE-PACKAGE(name="rnl-std-logic", version="0.4")
// }

// Ideal inverter: switches at V(VDD,VSS)/2; vt sets the step width, td the delay
subckt inverter (A Y VDD VSS)
parameters vt=10m td=10p
BhA (hA 0) bsource v=0.5*(1+tanh((v(A,VSS)-0.5*v(VDD,VSS))/vt))
Bf (nfn VSS) bsource v=v(VDD,VSS)*(1-v(hA))
Rd (nfn ndl) resistor r=1k
Cd (ndl VSS) capacitor c=td/1000
BY (Y VSS) bsource v=v(ndl,VSS)
ends inverter

subckt CG_CE (VDD VSS IN1 IN2 CLK OUT)
M1 (net3 IN1 VDD VDD) sky130_fd_pr__pfet_01v8 l=0.15 w=1 nf=1 m=1
M2 (net2 IN2 net3 VDD) sky130_fd_pr__pfet_01v8 l=0.15 w=1 nf=1 m=1
M3 (OUT CLK net2 VDD) sky130_fd_pr__pfet_01v8 l=0.15 w=1 nf=1 m=1
M4 (OUT CLKB net1 VSS) sky130_fd_pr__nfet_01v8 l=0.15 w=1 nf=1 m=1
M5 (net1 IN1 net0 VSS) sky130_fd_pr__nfet_01v8 l=0.15 w=1 nf=1 m=1
M6 (net0 IN2 VSS VSS) sky130_fd_pr__nfet_01v8 l=0.15 w=1 nf=1 m=1
X1 (CLK CLKB VDD VSS) inverter td=10p vt=10m
// @RNL(author="analog-canvas") {
//   %CG_CE_SYMBOL = @DEFINE-SYMBOL(box=[-5, -5, 5, 5]) {
//     (-5, 0) @PIN(terminal="IN1", label="\textbf{\textit{IN1}}", direction="left");
//     (-5, -2) @PIN(terminal="IN2", label="\textbf{\textit{IN2}}", direction="left");
//     (5, 0) @PIN(terminal="CLK", label="\textbf{\textit{CLK}}", direction="right");
//     (0, 5) @PIN(terminal="VDD", label="\textbf{\textit{V}}_{\textbf{DD}}", direction="up");
//     (5, -2) @PIN(terminal="OUT", label="\textbf{\textit{OUT}}", direction="right");
//     (0, 0) @RECTANGLE(width=8, height=8);
//     @LINE {(-5, 0) (-4, 0)};
//     @LINE {(-5, -2) (-4, -2)};
//     @LINE {(5, 0) (4, 0)};
//     @LINE {(0, 5) (0, 4)};
//     @LINE {(5, -2) (4, -2)}
//   };
//   # @SET-SYMBOL %CG_CE_SYMBOL;
//   $CANVAS_TYPESETTING @ATTACH(subscript_italic=false) #(level);
//   $CANVAS_CELL_NAME @ATTACH(name="CG-CE") #(level);
//   #M1 @SET-SYMBOL(terminals=[[1, "d"], [2, "g"], [3, "s"]]) $PMOS => @PLACE(42, -3) => @ORIENT("R0");
//   #M2 @SET-SYMBOL(terminals=[[1, "d"], [2, "g"], [3, "s"]]) $PMOS => @PLACE(42, -7) => @ORIENT("R0");
//   #M3 @SET-SYMBOL(terminals=[[1, "d"], [2, "g"], [3, "s"]]) $PMOS => @PLACE(42, -11) => @ORIENT("R0");
//   #M4 @SET-SYMBOL(terminals=[[1, "d"], [2, "g"], [3, "s"]]) $NMOS => @PLACE(42, -15) => @ORIENT("R0");
//   #M5 @SET-SYMBOL(terminals=[[1, "d"], [2, "g"], [3, "s"]]) $NMOS => @PLACE(42, -19) => @ORIENT("R0");
//   #M6 @SET-SYMBOL(terminals=[[1, "d"], [2, "g"], [3, "s"]]) $NMOS => @PLACE(42, -23) => @ORIENT("R0");
//   $IO_PORT @ATTACH &IN1(p) => @SET-SYMBOL $IO_PORT_SYMBOL => @PLACE(31, -3) => @ORIENT("R0") => %port1;
//   $IO_PORT @ATTACH &IN2(p) => @SET-SYMBOL $IO_PORT_SYMBOL => @PLACE(31, -23) => @ORIENT("R0") => %port2;
//   $IO_PORT @ATTACH &CLK(p) => @SET-SYMBOL $IO_PORT_SYMBOL => @PLACE(39, -11) => @ORIENT("R0") => %port3;
//   $SUPPLY @ATTACH &VDD(p) => @SET-SYMBOL $SUPPLY_SYMBOL => @PLACE(42, -2) => @ORIENT("R0") => %vdd1;
//   $IO_PORT @ATTACH &OUT(p) => @SET-SYMBOL $IO_PORT_SYMBOL => @PLACE(44, -13) => @ORIENT("MY") => %port4;
//   $GROUND @ATTACH &VSS(p) => @SET-SYMBOL $GROUND_SYMBOL => @PLACE(42, -24) => @ORIENT("R0") => %gnd1;
//   $IO_PORT @ATTACH &CLK(p) => @SET-SYMBOL $IO_PORT_SYMBOL => @PLACE(32, -31) => @ORIENT("R0") => %port5;
//   #X1 @SET-SYMBOL(terminals=[[1, "a"], [2, "y"]]) $INVERTER => @PLACE(35, -31) => @ORIENT("R0");
//   %j1 = (33, -3);
//   %j2 = (35, -23);
//   %j3 = (42, -31);
//   %j4 = (36, -15);
//   &IN1 @WIRE(mode="straight") {#M1:2 %j1};
//   &IN1 @WIRE(mode="straight") {%j1 (33, -19) #M5:2};
//   &IN2 @WIRE(mode="straight") {#M2:2 (35, -7) %j2};
//   &IN2 @WIRE(mode="straight") {%j2 #M6:2};
//   &IN1 @WIRE(mode="straight") {%port1::pin %j1};
//   &IN2 @WIRE(mode="straight") {%port2::pin %j2};
//   &VDD @WIRE(mode="straight") {#M1:3 %vdd1::pin};
//   &OUT @WIRE(mode="straight") {%port4::pin #M3:1};
//   &VSS @WIRE(mode="straight") {%gnd1::pin #M6:3};
//   &CLKB @WIRE(mode="straight") {#X1:2 %j3} => %wire1;
//   &CLKB @WIRE(mode="straight") {#M4:2 %j4};
//   &net0 @WIRE(mode="straight") {#M6:1 #M5:3};
//   &net1 @WIRE(mode="straight") {#M5:1 #M4:3};
//   &net2 @WIRE(mode="straight") {#M3:3 #M2:1};
//   &net3 @WIRE(mode="straight") {#M2:3 #M1:1};
//   $JUNCTION @ATTACH %j1(p) => @PLACE(33, -3) => %dot1;
//   &OUT @WIRE(mode="straight") {#M4:1 #M3:1};
//   $JUNCTION @ATTACH (42, -13)(p) => @PLACE(42, -13) => %dot2;
//   &CLK @WIRE(mode="straight") {%port3::pin #M3:2};
//   &CLK @WIRE(mode="straight") {%port5::pin #X1:1};
//   $JUNCTION @ATTACH %j2(p) => @PLACE(35, -23) => %dot3;
//   #M1
//       @TEXT("\textbf{\textit{M}}_{\textbf{1}}", key="name", dx=0.4, dy=-0.5, halign="start", valign="baseline", size=1.5116,
//       bold=false, textvisible=true);
//   $CANVAS_LABEL @ATTACH(bind="name") #M1::name(label);
//   #M2
//       @TEXT("\textbf{\textit{M}}_{\textbf{2}}", key="name", dx=0.4, dy=-0.5, halign="start", valign="baseline", size=1.5116,
//       bold=false, textvisible=true);
//   $CANVAS_LABEL @ATTACH(bind="name") #M2::name(label);
//   #M3
//       @TEXT("\textbf{\textit{M}}_{\textbf{3}}", key="name", dx=0.4, dy=-0.5, halign="start", valign="baseline", size=1.5116,
//       bold=false, textvisible=true);
//   $CANVAS_LABEL @ATTACH(bind="name") #M3::name(label);
//   #M4
//       @TEXT("\textbf{\textit{M}}_{\textbf{4}}", key="name", dx=0.5, dy=-0.5, halign="start", valign="baseline", size=1.5116,
//       bold=false, textvisible=true);
//   $CANVAS_LABEL @ATTACH(bind="name") #M4::name(label);
//   #M5
//       @TEXT("\textbf{\textit{M}}_{\textbf{5}}", key="name", dx=0.5, dy=-0.5, halign="start", valign="baseline", size=1.5116,
//       bold=false, textvisible=true);
//   $CANVAS_LABEL @ATTACH(bind="name") #M5::name(label);
//   #M6
//       @TEXT("\textbf{\textit{M}}_{\textbf{6}}", key="name", dx=0.5, dy=-0.5, halign="start", valign="baseline", size=1.5116,
//       bold=false, textvisible=true);
//   $CANVAS_LABEL @ATTACH(bind="name") #M6::name(label);
//   %port1
//       @TEXT("\textbf{\textit{IN1}}", key="netname", dx=-2, dy=-0.5, halign="end", valign="baseline", size=1.5116, bold=false,
//       textvisible=true);
//   $CANVAS_LABEL @ATTACH(bind="port") %port1::netname(label);
//   %port2
//       @TEXT("\textbf{\textit{IN2}}", key="netname", dx=-2, dy=-0.5, halign="end", valign="baseline", size=1.5116, bold=false,
//       textvisible=true);
//   $CANVAS_LABEL @ATTACH(bind="port") %port2::netname(label);
//   %port3
//       @TEXT("\textbf{\textit{CLK}}", key="netname", dx=-0.5, dy=1, halign="end", valign="baseline", size=1.5116, bold=false,
//       textvisible=true);
//   $CANVAS_LABEL @ATTACH(bind="port") %port3::netname(label);
//   %vdd1 @TEXT("\textbf{\textit{V}}_{\textbf{DD}}", dx=-1.5, dy=3, size=1.5116, bold=false) => %power1;
//   $CANVAS_LABEL @ATTACH(bind="port") %power1(label);
//   %port4
//       @TEXT("\textbf{\textit{OUT}}", key="netname", dx=2, dy=-0.5, halign="start", valign="baseline", size=1.5116, bold=false,
//       textvisible=true);
//   $CANVAS_LABEL @ATTACH(bind="port") %port4::netname(label);
//   %port5
//       @TEXT("\textbf{\textit{CLK}}", key="netname", dx=-0.5, dy=1, halign="end", valign="baseline", size=1.5116, bold=false,
//       textvisible=true);
//   $CANVAS_LABEL @ATTACH(bind="port") %port5::netname(label);
//   #X1
//       @TEXT("\textbf{\textit{X}}_{\textbf{1}}", key="name", dx=-0.5, dy=-2.9, halign="middle", valign="baseline", size=1.5116,
//       bold=false, textvisible=true);
//   $CANVAS_LABEL @ATTACH(bind="name") #X1::name(label);
//   %wire1 @TEXT("\textbf{\textit{CLKB}}", size=1.5116, bold=false) => @PLACE(39.43913, -30.6) => %label1;
//   $CANVAS_LABEL @ATTACH(bind="net") %label1(label);
//   &CLKB @TEXT("\textbf{\textit{CLKB}}", size=1.5116, bold=false) => @PLACE(35.5, -14.5) => %label2;
//   $CANVAS_LABEL @ATTACH(bind="net") %label2(label);
//   %vdd1 @TEXT("${p}", key="netname", textvisible=false)
// }
ends CG_CE

subckt dut (VDD VSS CLK CLKB D NCK I1 I2 I5 Q I3 I7 I4 I8 S3 S4 S5 S6 S7)
subckt ideal_switch (p n cp cn)
parameters ron=1 roff=1e12 vt=0.5
core (p n) bsource i=v(p,n)/(v(cp,cn)>vt ? ron : roff)
ends ideal_switch
M1 (I1 I4 VDD VDD) sky130_fd_pr__pfet_01v8 l=0.15 w=1 nf=1 m=1
M10 (I4 CLK net13 VDD) sky130_fd_pr__pfet_01v8 l=0.15 w=1 nf=1 m=1
M11 (I4 CLKB net5 VSS) sky130_fd_pr__nfet_01v8 l=0.15 w=1 nf=1 m=1
M12 (net5 I1 VSS VSS) sky130_fd_pr__nfet_01v8 l=0.15 w=1 nf=1 m=1
M13 (I3 I6 VDD VDD) sky130_fd_pr__pfet_01v8 l=0.15 w=1 nf=1 m=1
M14 (I3 I3b VSS VSS) sky130_fd_pr__nfet_01v8 l=0.15 w=1 nf=1 m=1
M15 (net14 I3 VDD VDD) sky130_fd_pr__pfet_01v8 l=0.15 w=1 nf=1 m=1
M16 (I3b CLK net14 VDD) sky130_fd_pr__pfet_01v8 l=0.15 w=1 nf=1 m=1
M17 (I3b CLKB net6 VSS) sky130_fd_pr__nfet_01v8 l=0.15 w=1 nf=1 m=1
M18 (net6 I4 VSS VSS) sky130_fd_pr__nfet_01v8 l=0.15 w=1 nf=1 m=1
M19 (I4 I3b VDD VDD) sky130_fd_pr__pfet_01v8 l=0.15 w=1 nf=1 m=1
M2 (I1 I1b VSS VSS) sky130_fd_pr__nfet_01v8 l=0.15 w=1 nf=1 m=1
M20 (I4 I6 VSS VSS) sky130_fd_pr__nfet_01v8 l=0.15 w=1 nf=1 m=1
M21 (net15 I4 VDD VDD) sky130_fd_pr__pfet_01v8 l=0.15 w=1 nf=1 m=1
M22 (I6 CLK net15 VDD) sky130_fd_pr__pfet_01v8 l=0.15 w=1 nf=1 m=1
M23 (I6 CLKB net7 VSS) sky130_fd_pr__nfet_01v8 l=0.15 w=1 nf=1 m=1
M24 (net7 I3 VSS VSS) sky130_fd_pr__nfet_01v8 l=0.15 w=1 nf=1 m=1
M25 (I6 I5b VDD VDD) sky130_fd_pr__pfet_01v8 l=0.15 w=1 nf=1 m=1
M26 (I6 I8 VSS VSS) sky130_fd_pr__nfet_01v8 l=0.15 w=1 nf=1 m=1
M27 (net9 I6 VDD VDD) sky130_fd_pr__pfet_01v8 l=0.15 w=1 nf=1 m=1
M28 (I8 CLK net9 VDD) sky130_fd_pr__pfet_01v8 l=0.15 w=1 nf=1 m=1
M29 (I8 CLKB net1 VSS) sky130_fd_pr__nfet_01v8 l=0.15 w=1 nf=1 m=1
M3 (net8 I1 VDD VDD) sky130_fd_pr__pfet_01v8 l=0.15 w=1 nf=1 m=1
M30 (net1 I5 VSS VSS) sky130_fd_pr__nfet_01v8 l=0.15 w=1 nf=1 m=1
M31 (I5 I8 VDD VDD) sky130_fd_pr__pfet_01v8 l=0.15 w=1 nf=1 m=1
M32 (I5 I5b VSS VSS) sky130_fd_pr__nfet_01v8 l=0.15 w=1 nf=1 m=1
M33 (net10 I5 VDD VDD) sky130_fd_pr__pfet_01v8 l=0.15 w=1 nf=1 m=1
M34 (I5b CLK net10 VDD) sky130_fd_pr__pfet_01v8 l=0.15 w=1 nf=1 m=1
M35 (I5b CLKB net2 VSS) sky130_fd_pr__nfet_01v8 l=0.15 w=1 nf=1 m=1
M36 (net2 I6 VSS VSS) sky130_fd_pr__nfet_01v8 l=0.15 w=1 nf=1 m=1
M37 (I8 I7b VDD VDD) sky130_fd_pr__pfet_01v8 l=0.15 w=1 nf=1 m=1
M38 (I8 I2a VSS VSS) sky130_fd_pr__nfet_01v8 l=0.15 w=1 nf=1 m=1
M39 (net11 I8 VDD VDD) sky130_fd_pr__pfet_01v8 l=0.15 w=1 nf=1 m=1
M4 (I1b CLK net8 VDD) sky130_fd_pr__pfet_01v8 l=0.15 w=1 nf=1 m=1
M40 (I2a CLK net11 VDD) sky130_fd_pr__pfet_01v8 l=0.15 w=1 nf=1 m=1
M41 (I2a CLKB net3 VSS) sky130_fd_pr__nfet_01v8 l=0.15 w=1 nf=1 m=1
M42 (net3 I7 VSS VSS) sky130_fd_pr__nfet_01v8 l=0.15 w=1 nf=1 m=1
M43 (I7 I2a VDD VDD) sky130_fd_pr__pfet_01v8 l=0.15 w=1 nf=1 m=1
M44 (I7 I7b VSS VSS) sky130_fd_pr__nfet_01v8 l=0.15 w=1 nf=1 m=1
M45 (net12 I7 VDD VDD) sky130_fd_pr__pfet_01v8 l=0.15 w=1 nf=1 m=1
M46 (I7b CLK net12 VDD) sky130_fd_pr__pfet_01v8 l=0.15 w=1 nf=1 m=1
M47 (I7b CLKB net4 VSS) sky130_fd_pr__nfet_01v8 l=0.15 w=1 nf=1 m=1
M48 (net4 I8 VSS VSS) sky130_fd_pr__nfet_01v8 l=0.15 w=1 nf=1 m=1
M5 (I1b CLKB net0 VSS) sky130_fd_pr__nfet_01v8 l=0.15 w=1 nf=1 m=1
M6 (net0 I2 VSS VSS) sky130_fd_pr__nfet_01v8 l=0.15 w=1 nf=1 m=1
M7 (I2 I1b VDD VDD) sky130_fd_pr__pfet_01v8 l=0.15 w=1 nf=1 m=1
M8 (I2 I4 VSS VSS) sky130_fd_pr__nfet_01v8 l=0.15 w=1 nf=1 m=1
M9 (net13 I2 VDD VDD) sky130_fd_pr__pfet_01v8 l=0.15 w=1 nf=1 m=1
S1 (I2 I2a CLK VSS) ideal_switch
S2 (I1 D NCK VSS) ideal_switch
S3 (I2 D S3 VSS) ideal_switch
S4 (I5 D S4 VSS) ideal_switch
S5 (Q D S5 VSS) ideal_switch
S6 (I3 net16 S6 VSS) ideal_switch
S7 (I7 net16 S7 VSS) ideal_switch
X1 (D net16 VDD VSS) inverter td=10p vt=10m
X2 (VDD VSS I4 I8 CLK Q) CG_CE
// @RNL(author="analog-canvas") {
//   %dut_SYMBOL = @DEFINE-SYMBOL(box=[-5, -13, 5, 13]) {
//     (0, 13) @PIN(terminal="VDD", label="\textbf{\textit{V}}_{\textbf{DD}}", direction="up");
//     (-5, 8) @PIN(terminal="CLK", label="\textbf{\textit{CLK}}", direction="left");
//     (-5, 6) @PIN(terminal="CLKB", label="\textbf{\textit{CLKB}}", direction="left");
//     (-5, -10) @PIN(terminal="D", label="\textbf{\textit{D}}", direction="left");
//     (-5, -8) @PIN(terminal="NCK", label="\textbf{\textit{NCK}}", direction="left");
//     (-5, 4) @PIN(terminal="I1", label="\textbf{\textit{I}}_{\textbf{1}}", direction="left");
//     (-5, 2) @PIN(terminal="I2", label="\textbf{\textit{I}}_{\textbf{2}}", direction="left");
//     (-5, 0) @PIN(terminal="I5", label="\textbf{\textit{I}}_{\textbf{5}}", direction="left");
//     (-5, -2) @PIN(terminal="Q", label="\textbf{\textit{Q}}", direction="left");
//     (-5, -4) @PIN(terminal="I3", label="\textbf{\textit{I}}_{\textbf{3}}", direction="left");
//     (-5, -6) @PIN(terminal="I7", label="\textbf{\textit{I}}_{\textbf{7}}", direction="left");
//     (5, 0) @PIN(terminal="I4", label="\textbf{\textit{I}}_{\textbf{4}}", direction="right");
//     (5, -2) @PIN(terminal="I8", label="\textbf{\textit{I}}_{\textbf{8}}", direction="right");
//     (0, 0) @RECTANGLE(width=8, height=24);
//     @LINE {(0, 13) (0, 12)};
//     @LINE {(-5, 8) (-4, 8)};
//     @LINE {(-5, 6) (-4, 6)};
//     @LINE {(-5, -10) (-4, -10)};
//     @LINE {(-5, -8) (-4, -8)};
//     @LINE {(-5, 4) (-4, 4)};
//     @LINE {(-5, 2) (-4, 2)};
//     @LINE {(-5, 0) (-4, 0)};
//     @LINE {(-5, -2) (-4, -2)};
//     @LINE {(-5, -4) (-4, -4)};
//     @LINE {(-5, -6) (-4, -6)};
//     @LINE {(5, 0) (4, 0)};
//     @LINE {(5, -2) (4, -2)}
//   };
//   # @SET-SYMBOL %dut_SYMBOL;
//   $CANVAS_TYPESETTING @ATTACH(subscript_italic=false) #(level);
//   #M1 @SET-SYMBOL(terminals=[[1, "d"], [2, "g"], [3, "s"]]) $PMOS => @PLACE(48, -14) => @ORIENT("R0");
//   #M2 @SET-SYMBOL(terminals=[[1, "d"], [2, "g"], [3, "s"]]) $NMOS => @PLACE(48, -26) => @ORIENT("MY");
//   #M3 @SET-SYMBOL(terminals=[[1, "d"], [2, "g"], [3, "s"]]) $PMOS => @PLACE(59, -14) => @ORIENT("R0");
//   #M4 @SET-SYMBOL(terminals=[[1, "d"], [2, "g"], [3, "s"]]) $PMOS => @PLACE(59, -18) => @ORIENT("R0");
//   #M5 @SET-SYMBOL(terminals=[[1, "d"], [2, "g"], [3, "s"]]) $NMOS => @PLACE(59, -22) => @ORIENT("MY");
//   #M6 @SET-SYMBOL(terminals=[[1, "d"], [2, "g"], [3, "s"]]) $NMOS => @PLACE(59, -26) => @ORIENT("MY");
//   #M7 @SET-SYMBOL(terminals=[[1, "d"], [2, "g"], [3, "s"]]) $PMOS => @PLACE(70, -14) => @ORIENT("R0");
//   #M8 @SET-SYMBOL(terminals=[[1, "d"], [2, "g"], [3, "s"]]) $NMOS => @PLACE(70, -26) => @ORIENT("MY");
//   #M9 @SET-SYMBOL(terminals=[[1, "d"], [2, "g"], [3, "s"]]) $PMOS => @PLACE(81, -14) => @ORIENT("R0");
//   #M10 @SET-SYMBOL(terminals=[[1, "d"], [2, "g"], [3, "s"]]) $PMOS => @PLACE(81, -18) => @ORIENT("R0");
//   #M11 @SET-SYMBOL(terminals=[[1, "d"], [2, "g"], [3, "s"]]) $NMOS => @PLACE(81, -22) => @ORIENT("MY");
//   #M12 @SET-SYMBOL(terminals=[[1, "d"], [2, "g"], [3, "s"]]) $NMOS => @PLACE(81, -26) => @ORIENT("MY");
//   $SUPPLY @ATTACH &VDD(p) => @SET-SYMBOL $SUPPLY_SYMBOL => @PLACE(48, -13) => @ORIENT("R0") => %vdd1;
//   $SUPPLY @ATTACH &VDD(p) => @SET-SYMBOL $SUPPLY_SYMBOL => @PLACE(59, -13) => @ORIENT("R0") => %vdd2;
//   $SUPPLY @ATTACH &VDD(p) => @SET-SYMBOL $SUPPLY_SYMBOL => @PLACE(70, -13) => @ORIENT("R0") => %vdd3;
//   $SUPPLY @ATTACH &VDD(p) => @SET-SYMBOL $SUPPLY_SYMBOL => @PLACE(81, -13) => @ORIENT("R0") => %vdd4;
//   $GROUND @ATTACH &VSS(p) => @SET-SYMBOL $GROUND_SYMBOL => @PLACE(48, -27) => @ORIENT("R0") => %gnd1;
//   $GROUND @ATTACH &VSS(p) => @SET-SYMBOL $GROUND_SYMBOL => @PLACE(59, -27) => @ORIENT("R0") => %gnd2;
//   $GROUND @ATTACH &VSS(p) => @SET-SYMBOL $GROUND_SYMBOL => @PLACE(70, -27) => @ORIENT("R0") => %gnd3;
//   $GROUND @ATTACH &VSS(p) => @SET-SYMBOL $GROUND_SYMBOL => @PLACE(81, -27) => @ORIENT("R0") => %gnd4;
//   $IO_PORT @ATTACH &CLK(p) => @SET-SYMBOL $IO_PORT_SYMBOL => @PLACE(56, -18) => @ORIENT("R0") => %port1;
//   $IO_PORT @ATTACH &CLKB(p) => @SET-SYMBOL $IO_PORT_SYMBOL => @PLACE(62, -22) => @ORIENT("MY") => %port2;
//   $IO_PORT @ATTACH &CLK(p) => @SET-SYMBOL $IO_PORT_SYMBOL => @PLACE(78, -18) => @ORIENT("R0") => %port3;
//   $IO_PORT @ATTACH &CLKB(p) => @SET-SYMBOL $IO_PORT_SYMBOL => @PLACE(84, -22) => @ORIENT("MY") => %port4;
//   #M13 @SET-SYMBOL(terminals=[[1, "d"], [2, "g"], [3, "s"]]) $PMOS => @PLACE(98, -14) => @ORIENT("R0");
//   #M14 @SET-SYMBOL(terminals=[[1, "d"], [2, "g"], [3, "s"]]) $NMOS => @PLACE(98, -26) => @ORIENT("MY");
//   #M15 @SET-SYMBOL(terminals=[[1, "d"], [2, "g"], [3, "s"]]) $PMOS => @PLACE(109, -14) => @ORIENT("R0");
//   #M16 @SET-SYMBOL(terminals=[[1, "d"], [2, "g"], [3, "s"]]) $PMOS => @PLACE(109, -18) => @ORIENT("R0");
//   #M17 @SET-SYMBOL(terminals=[[1, "d"], [2, "g"], [3, "s"]]) $NMOS => @PLACE(109, -22) => @ORIENT("MY");
//   #M18 @SET-SYMBOL(terminals=[[1, "d"], [2, "g"], [3, "s"]]) $NMOS => @PLACE(109, -26) => @ORIENT("MY");
//   #M19 @SET-SYMBOL(terminals=[[1, "d"], [2, "g"], [3, "s"]]) $PMOS => @PLACE(120, -14) => @ORIENT("R0");
//   #M20 @SET-SYMBOL(terminals=[[1, "d"], [2, "g"], [3, "s"]]) $NMOS => @PLACE(120, -26) => @ORIENT("MY");
//   #M21 @SET-SYMBOL(terminals=[[1, "d"], [2, "g"], [3, "s"]]) $PMOS => @PLACE(131, -14) => @ORIENT("R0");
//   #M22 @SET-SYMBOL(terminals=[[1, "d"], [2, "g"], [3, "s"]]) $PMOS => @PLACE(131, -18) => @ORIENT("R0");
//   #M23 @SET-SYMBOL(terminals=[[1, "d"], [2, "g"], [3, "s"]]) $NMOS => @PLACE(131, -22) => @ORIENT("MY");
//   #M24 @SET-SYMBOL(terminals=[[1, "d"], [2, "g"], [3, "s"]]) $NMOS => @PLACE(131, -26) => @ORIENT("MY");
//   $SUPPLY @ATTACH &VDD(p) => @SET-SYMBOL $SUPPLY_SYMBOL => @PLACE(98, -13) => @ORIENT("R0") => %vdd5;
//   $SUPPLY @ATTACH &VDD(p) => @SET-SYMBOL $SUPPLY_SYMBOL => @PLACE(109, -13) => @ORIENT("R0") => %vdd6;
//   $SUPPLY @ATTACH &VDD(p) => @SET-SYMBOL $SUPPLY_SYMBOL => @PLACE(120, -13) => @ORIENT("R0") => %vdd7;
//   $SUPPLY @ATTACH &VDD(p) => @SET-SYMBOL $SUPPLY_SYMBOL => @PLACE(131, -13) => @ORIENT("R0") => %vdd8;
//   $GROUND @ATTACH &VSS(p) => @SET-SYMBOL $GROUND_SYMBOL => @PLACE(98, -27) => @ORIENT("R0") => %gnd5;
//   $GROUND @ATTACH &VSS(p) => @SET-SYMBOL $GROUND_SYMBOL => @PLACE(109, -27) => @ORIENT("R0") => %gnd6;
//   $GROUND @ATTACH &VSS(p) => @SET-SYMBOL $GROUND_SYMBOL => @PLACE(120, -27) => @ORIENT("R0") => %gnd7;
//   $GROUND @ATTACH &VSS(p) => @SET-SYMBOL $GROUND_SYMBOL => @PLACE(131, -27) => @ORIENT("R0") => %gnd8;
//   $IO_PORT @ATTACH &CLK(p) => @SET-SYMBOL $IO_PORT_SYMBOL => @PLACE(106, -18) => @ORIENT("R0") => %port5;
//   $IO_PORT @ATTACH &CLKB(p) => @SET-SYMBOL $IO_PORT_SYMBOL => @PLACE(112, -22) => @ORIENT("MY") => %port6;
//   $IO_PORT @ATTACH &CLK(p) => @SET-SYMBOL $IO_PORT_SYMBOL => @PLACE(128, -18) => @ORIENT("R0") => %port7;
//   $IO_PORT @ATTACH &CLKB(p) => @SET-SYMBOL $IO_PORT_SYMBOL => @PLACE(134, -22) => @ORIENT("MY") => %port8;
//   #M25 @SET-SYMBOL(terminals=[[1, "d"], [2, "g"], [3, "s"]]) $PMOS => @PLACE(131, -43) => @ORIENT("MY");
//   #M26 @SET-SYMBOL(terminals=[[1, "d"], [2, "g"], [3, "s"]]) $NMOS => @PLACE(131, -55) => @ORIENT("R0");
//   #M27 @SET-SYMBOL(terminals=[[1, "d"], [2, "g"], [3, "s"]]) $PMOS => @PLACE(120, -43) => @ORIENT("MY");
//   #M28 @SET-SYMBOL(terminals=[[1, "d"], [2, "g"], [3, "s"]]) $PMOS => @PLACE(120, -47) => @ORIENT("MY");
//   #M29 @SET-SYMBOL(terminals=[[1, "d"], [2, "g"], [3, "s"]]) $NMOS => @PLACE(120, -51) => @ORIENT("R0");
//   #M30 @SET-SYMBOL(terminals=[[1, "d"], [2, "g"], [3, "s"]]) $NMOS => @PLACE(120, -55) => @ORIENT("R0");
//   #M31 @SET-SYMBOL(terminals=[[1, "d"], [2, "g"], [3, "s"]]) $PMOS => @PLACE(109, -43) => @ORIENT("MY");
//   #M32 @SET-SYMBOL(terminals=[[1, "d"], [2, "g"], [3, "s"]]) $NMOS => @PLACE(109, -55) => @ORIENT("R0");
//   #M33 @SET-SYMBOL(terminals=[[1, "d"], [2, "g"], [3, "s"]]) $PMOS => @PLACE(98, -43) => @ORIENT("MY");
//   #M34 @SET-SYMBOL(terminals=[[1, "d"], [2, "g"], [3, "s"]]) $PMOS => @PLACE(98, -47) => @ORIENT("MY");
//   #M35 @SET-SYMBOL(terminals=[[1, "d"], [2, "g"], [3, "s"]]) $NMOS => @PLACE(98, -51) => @ORIENT("R0");
//   #M36 @SET-SYMBOL(terminals=[[1, "d"], [2, "g"], [3, "s"]]) $NMOS => @PLACE(98, -55) => @ORIENT("R0");
//   $SUPPLY @ATTACH &VDD(p) => @SET-SYMBOL $SUPPLY_SYMBOL => @PLACE(131, -42) => @ORIENT("MY") => %vdd9;
//   $SUPPLY @ATTACH &VDD(p) => @SET-SYMBOL $SUPPLY_SYMBOL => @PLACE(120, -42) => @ORIENT("MY") => %vdd10;
//   $SUPPLY @ATTACH &VDD(p) => @SET-SYMBOL $SUPPLY_SYMBOL => @PLACE(109, -42) => @ORIENT("MY") => %vdd11;
//   $SUPPLY @ATTACH &VDD(p) => @SET-SYMBOL $SUPPLY_SYMBOL => @PLACE(98, -42) => @ORIENT("MY") => %vdd12;
//   $GROUND @ATTACH &VSS(p) => @SET-SYMBOL $GROUND_SYMBOL => @PLACE(131, -56) => @ORIENT("MY") => %gnd9;
//   $GROUND @ATTACH &VSS(p) => @SET-SYMBOL $GROUND_SYMBOL => @PLACE(120, -56) => @ORIENT("MY") => %gnd10;
//   $GROUND @ATTACH &VSS(p) => @SET-SYMBOL $GROUND_SYMBOL => @PLACE(109, -56) => @ORIENT("MY") => %gnd11;
//   $GROUND @ATTACH &VSS(p) => @SET-SYMBOL $GROUND_SYMBOL => @PLACE(98, -56) => @ORIENT("MY") => %gnd12;
//   $IO_PORT @ATTACH &CLK(p) => @SET-SYMBOL $IO_PORT_SYMBOL => @PLACE(123, -47) => @ORIENT("MY") => %port9;
//   $IO_PORT @ATTACH &CLKB(p) => @SET-SYMBOL $IO_PORT_SYMBOL => @PLACE(117, -51) => @ORIENT("R0") => %port10;
//   $IO_PORT @ATTACH &CLK(p) => @SET-SYMBOL $IO_PORT_SYMBOL => @PLACE(101, -47) => @ORIENT("MY") => %port11;
//   $IO_PORT @ATTACH &CLKB(p) => @SET-SYMBOL $IO_PORT_SYMBOL => @PLACE(95, -51) => @ORIENT("R0") => %port12;
//   #M37 @SET-SYMBOL(terminals=[[1, "d"], [2, "g"], [3, "s"]]) $PMOS => @PLACE(81, -43) => @ORIENT("MY");
//   #M38 @SET-SYMBOL(terminals=[[1, "d"], [2, "g"], [3, "s"]]) $NMOS => @PLACE(81, -55) => @ORIENT("R0");
//   #M39 @SET-SYMBOL(terminals=[[1, "d"], [2, "g"], [3, "s"]]) $PMOS => @PLACE(70, -43) => @ORIENT("MY");
//   #M40 @SET-SYMBOL(terminals=[[1, "d"], [2, "g"], [3, "s"]]) $PMOS => @PLACE(70, -47) => @ORIENT("MY");
//   #M41 @SET-SYMBOL(terminals=[[1, "d"], [2, "g"], [3, "s"]]) $NMOS => @PLACE(70, -51) => @ORIENT("R0");
//   #M42 @SET-SYMBOL(terminals=[[1, "d"], [2, "g"], [3, "s"]]) $NMOS => @PLACE(70, -55) => @ORIENT("R0");
//   #M43 @SET-SYMBOL(terminals=[[1, "d"], [2, "g"], [3, "s"]]) $PMOS => @PLACE(59, -43) => @ORIENT("MY");
//   #M44 @SET-SYMBOL(terminals=[[1, "d"], [2, "g"], [3, "s"]]) $NMOS => @PLACE(59, -55) => @ORIENT("R0");
//   #M45 @SET-SYMBOL(terminals=[[1, "d"], [2, "g"], [3, "s"]]) $PMOS => @PLACE(48, -43) => @ORIENT("MY");
//   #M46 @SET-SYMBOL(terminals=[[1, "d"], [2, "g"], [3, "s"]]) $PMOS => @PLACE(48, -47) => @ORIENT("MY");
//   #M47 @SET-SYMBOL(terminals=[[1, "d"], [2, "g"], [3, "s"]]) $NMOS => @PLACE(48, -51) => @ORIENT("R0");
//   #M48 @SET-SYMBOL(terminals=[[1, "d"], [2, "g"], [3, "s"]]) $NMOS => @PLACE(48, -55) => @ORIENT("R0");
//   $SUPPLY @ATTACH &VDD(p) => @SET-SYMBOL $SUPPLY_SYMBOL => @PLACE(81, -42) => @ORIENT("MY") => %vdd13;
//   $SUPPLY @ATTACH &VDD(p) => @SET-SYMBOL $SUPPLY_SYMBOL => @PLACE(70, -42) => @ORIENT("MY") => %vdd14;
//   $SUPPLY @ATTACH &VDD(p) => @SET-SYMBOL $SUPPLY_SYMBOL => @PLACE(59, -42) => @ORIENT("MY") => %vdd15;
//   $SUPPLY @ATTACH &VDD(p) => @SET-SYMBOL $SUPPLY_SYMBOL => @PLACE(48, -42) => @ORIENT("MY") => %vdd16;
//   $GROUND @ATTACH &VSS(p) => @SET-SYMBOL $GROUND_SYMBOL => @PLACE(81, -56) => @ORIENT("MY") => %gnd13;
//   $GROUND @ATTACH &VSS(p) => @SET-SYMBOL $GROUND_SYMBOL => @PLACE(70, -56) => @ORIENT("MY") => %gnd14;
//   $GROUND @ATTACH &VSS(p) => @SET-SYMBOL $GROUND_SYMBOL => @PLACE(59, -56) => @ORIENT("MY") => %gnd15;
//   $GROUND @ATTACH &VSS(p) => @SET-SYMBOL $GROUND_SYMBOL => @PLACE(48, -56) => @ORIENT("MY") => %gnd16;
//   $IO_PORT @ATTACH &CLK(p) => @SET-SYMBOL $IO_PORT_SYMBOL => @PLACE(73, -47) => @ORIENT("MY") => %port13;
//   $IO_PORT @ATTACH &CLKB(p) => @SET-SYMBOL $IO_PORT_SYMBOL => @PLACE(67, -51) => @ORIENT("R0") => %port14;
//   $IO_PORT @ATTACH &CLK(p) => @SET-SYMBOL $IO_PORT_SYMBOL => @PLACE(51, -47) => @ORIENT("MY") => %port15;
//   $IO_PORT @ATTACH &CLKB(p) => @SET-SYMBOL $IO_PORT_SYMBOL => @PLACE(45, -51) => @ORIENT("R0") => %port16;
//   #S1 @SET-SYMBOL(terminals=[[1, "p"], [2, "n"], [3, "cp"]]) $EXTERNALLY_CONTROLLED_SWITCH => @PLACE(62, -35) => @ORIENT("MY");
//   $IO_PORT @ATTACH &CLK(p) => @SET-SYMBOL $IO_PORT_SYMBOL => @PLACE(64, -35) => @ORIENT("MY") => %port17;
//   #S2 @SET-SYMBOL(terminals=[[1, "p"], [2, "n"], [3, "cp"]]) $EXTERNALLY_CONTROLLED_SWITCH => @PLACE(56, -73) => @ORIENT("R0");
//   #S3 @SET-SYMBOL(terminals=[[1, "p"], [2, "n"]]) $SWITCH => @PLACE(61, -73) => @ORIENT("MYR90");
//   #S4 @SET-SYMBOL(terminals=[[1, "p"], [2, "n"]]) $SWITCH => @PLACE(66, -73) => @ORIENT("MYR90");
//   #S5 @SET-SYMBOL(terminals=[[1, "p"], [2, "n"]]) $SWITCH => @PLACE(71, -73) => @ORIENT("MYR90");
//   $IO_PORT @ATTACH &D(p) => @SET-SYMBOL $IO_PORT_SYMBOL => @PLACE(54, -78) => @ORIENT("R0") => %port18;
//   $IO_PORT @ATTACH &NCK(p) => @SET-SYMBOL $IO_PORT_SYMBOL => @PLACE(54, -73) => @ORIENT("R0") => %port19;
//   $IO_PORT @ATTACH &I1(p) => @SET-SYMBOL $IO_PORT_SYMBOL => @PLACE(56, -71) => @ORIENT("R270") => %port20;
//   $IO_PORT @ATTACH &I2(p) => @SET-SYMBOL $IO_PORT_SYMBOL => @PLACE(61, -71) => @ORIENT("R270") => %port21;
//   $IO_PORT @ATTACH &I5(p) => @SET-SYMBOL $IO_PORT_SYMBOL => @PLACE(66, -71) => @ORIENT("R270") => %port22;
//   $IO_PORT @ATTACH &Q(p) => @SET-SYMBOL $IO_PORT_SYMBOL => @PLACE(71, -71) => @ORIENT("R270") => %port23;
//   #X1 @SET-SYMBOL(terminals=[[1, "a"], [2, "y"]]) $INVERTER => @PLACE(77, -78) => @ORIENT("R0");
//   #S6 @SET-SYMBOL(terminals=[[1, "p"], [2, "n"]]) $SWITCH => @PLACE(81, -73) => @ORIENT("MYR90");
//   #S7 @SET-SYMBOL(terminals=[[1, "p"], [2, "n"]]) $SWITCH => @PLACE(87, -73) => @ORIENT("MYR90");
//   $IO_PORT @ATTACH &I3(p) => @SET-SYMBOL $IO_PORT_SYMBOL => @PLACE(81, -71) => @ORIENT("R270") => %port24;
//   $IO_PORT @ATTACH &I7(p) => @SET-SYMBOL $IO_PORT_SYMBOL => @PLACE(87, -71) => @ORIENT("R270") => %port25;
//   #X2 @PLACE(111, -75) => @ORIENT("R0");
//   $IO_PORT @ATTACH &I4(p) => @SET-SYMBOL $IO_PORT_SYMBOL => @PLACE(106, -75) => @ORIENT("R0") => %port26;
//   $IO_PORT @ATTACH &I8(p) => @SET-SYMBOL $IO_PORT_SYMBOL => @PLACE(106, -77) => @ORIENT("R0") => %port27;
//   $SUPPLY @ATTACH &VDD(p) => @SET-SYMBOL $SUPPLY_SYMBOL => @PLACE(111, -70) => @ORIENT("MY") => %vdd17;
//   $IO_PORT @ATTACH &CLK(p) => @SET-SYMBOL $IO_PORT_SYMBOL => @PLACE(116, -75) => @ORIENT("MY") => %port28;
//   $IO_PORT @ATTACH &Q(p) => @SET-SYMBOL $IO_PORT_SYMBOL => @PLACE(116, -77) => @ORIENT("MY") => %port29;
//   %j1 = (48, -20);
//   %j2 = (70, -20);
//   %j3 = (67, -14);
//   %j4 = (98, -20);
//   %j5 = (120, -20);
//   %j6 = (117, -14);
//   %j7 = (87, -20);
//   %j8 = (131, -49);
//   %j9 = (109, -49);
//   %j10 = (112, -43);
//   %j11 = (117, -55);
//   %j12 = (81, -49);
//   %j13 = (59, -49);
//   %j14 = (135, -49);
//   %j15 = (137, -20);
//   %j16 = (85, -60);
//   %j17 = (61, -78);
//   %j18 = (66, -78);
//   %j19 = (56, -78);
//   %j20 = (71, -78);
//   %j21 = (81, -78);
//   %j22 = (67, -55);
//   %j23 = (59, -49);
//   &I1 @WIRE(mode="straight") {#M2:1 %j1};
//   &I1 @WIRE(mode="straight") {%j1 #M1:1};
//   &I1 @WIRE(mode="straight") {%j1 (50, -20) #M3:2} => %wire1;
//   &I1b @WIRE(mode="straight") {#M2:2 (57, -20) #M4:1};
//   &I1b @WIRE(mode="straight") {#M4:1 (61, -20) %j3} => %wire2;
//   &VSS @WIRE(mode="straight") {%gnd1::pin #M2:3};
//   &VSS @WIRE(mode="straight") {%gnd2::pin #M6:3};
//   &VSS @WIRE(mode="straight") {%gnd3::pin #M8:3};
//   &VSS @WIRE(mode="straight") {%gnd4::pin #M12:3};
//   &I1 @WIRE(mode="straight") {#M12:2 (87, -26) (87, -31) (44, -31) (44, -20) %j1};
//   &I3 @WIRE(mode="straight") {#M14:1 %j4};
//   &I3 @WIRE(mode="straight") {%j4 #M13:1};
//   &I3 @WIRE(mode="straight") {%j4 (100, -20) #M15:2} => %wire3;
//   &I3b @WIRE(mode="straight") {#M14:2 (107, -20) #M16:1};
//   &I3b @WIRE(mode="straight") {#M16:1 (111, -20) %j6} => %wire4;
//   &VSS @WIRE(mode="straight") {%gnd5::pin #M14:3};
//   &VSS @WIRE(mode="straight") {%gnd6::pin #M18:3};
//   &VSS @WIRE(mode="straight") {%gnd7::pin #M20:3};
//   &VSS @WIRE(mode="straight") {%gnd8::pin #M24:3};
//   &I3 @WIRE(mode="straight") {#M24:2 (137, -26) (137, -31) (94, -31) (94, -20) %j4};
//   &I4 @WIRE(mode="straight") {#M19:1 %j5};
//   &I4 @WIRE(mode="straight") {%j5 #M20:1};
//   &I4 @WIRE(mode="straight") {%j5 (122, -20) #M21:2} => %wire5;
//   &I4 @WIRE(mode="straight") {%j5 (118, -20) (112, -26) (112, -33) (91, -33) (91, -20) %j7};
//   &I4 @WIRE(mode="straight") {#M1:2 (44, -14) (44, -9) (87, -9) %j7} => %wire6;
//   &I4 @WIRE(mode="straight") {#M8:2 (79, -20) #M10:1};
//   &I4 @WIRE(mode="straight") {#M10:1 %j7};
//   &I5 @WIRE(mode="straight") {%j11 (111, -49) %j9};
//   &I5 @WIRE(mode="straight") {#M31:1 %j9};
//   &I5 @WIRE(mode="straight") {%j9 #M32:1};
//   &I5 @WIRE(mode="straight") {%j9 (107, -49) #M33:2} => %wire7;
//   &VSS @WIRE(mode="straight") {%gnd9::pin #M26:3};
//   &VSS @WIRE(mode="straight") {%gnd10::pin #M30:3};
//   &VSS @WIRE(mode="straight") {%gnd11::pin #M32:3};
//   &VSS @WIRE(mode="straight") {%gnd12::pin #M36:3};
//   &I7b @WIRE(mode="straight") {#M46:1 (50, -49) #M44:2};
//   &VSS @WIRE(mode="straight") {%gnd13::pin #M38:3};
//   &VSS @WIRE(mode="straight") {%gnd14::pin #M42:3};
//   &VSS @WIRE(mode="straight") {%gnd15::pin #M44:3};
//   &VSS @WIRE(mode="straight") {%gnd16::pin #M48:3};
//   &I7b @WIRE(mode="straight") {#M37:2 (85, -43) (85, -38) (42, -38) (42, -49) #M46:1} => %wire8;
//   &I7 @WIRE(mode="straight") {#M43:1 %j13};
//   &I7 @WIRE(mode="straight") {%j13 #M44:1};
//   &I7 @WIRE(mode="straight") {%j13 (57, -49) #M45:2} => %wire9;
//   &I6 @WIRE(mode="straight") {#M20:2 (129, -20) #M22:1};
//   &I6 @WIRE(mode="straight") {#M27:2 (129, -49) %j8};
//   &I6 @WIRE(mode="straight") {#M22:1 %j15};
//   &I6 @WIRE(mode="straight") {#M25:1 %j8};
//   &I6 @WIRE(mode="straight") {%j8 #M26:1};
//   &I6 @WIRE(mode="straight") {%j8 %j14};
//   &I6 @WIRE(mode="straight") {%j15 (141, -20) (141, -49) %j14};
//   &I6 @WIRE(mode="straight") {%j15 (137, -9) (94, -9) (94, -14) #M13:2} => %wire10;
//   &I6 @WIRE(mode="straight") {%j14 (135, -60) (92, -60) (92, -55) #M36:2};
//   &I5b @WIRE(mode="straight") {#M34:1 (100, -49) #M32:2};
//   &I5b @WIRE(mode="straight") {#M34:1 (92, -49) (92, -38) (135, -38) (135, -43) #M25:2} => %wire11;
//   &I8 @WIRE(mode="straight") {%j10 (118, -49) #M28:1} => %wire12;
//   &I8 @WIRE(mode="straight") {#M28:1 (122, -49) #M26:2};
//   &I8 @WIRE(mode="straight") {#M26:2 (128, -63) (85, -63) %j16};
//   &I8 @WIRE(mode="straight") {#M48:2 (42, -55) (42, -60) %j16};
//   &I8 @WIRE(mode="straight") {#M39:2 (79, -49) %j12} => %wire13;
//   &I8 @WIRE(mode="straight") {#M37:1 %j12};
//   &I8 @WIRE(mode="straight") {%j12 #M38:1};
//   &I8 @WIRE(mode="straight") {%j12 (85, -49) %j16};
//   &I2 @WIRE(mode="straight") {#S1:1 (62, -26) (68, -20) %j2};
//   &I2 @WIRE(mode="straight") {#M7:1 %j2};
//   &I2 @WIRE(mode="straight") {%j2 #M8:1};
//   &I2 @WIRE(mode="straight") {%j2 (72, -20) #M9:2} => %wire14;
//   &I2a @WIRE(mode="straight") {#S1:2 (62, -43) (68, -49) #M40:1} => %wire15;
//   &I2a @WIRE(mode="straight") {#M40:1 (72, -49) #M38:2};
//   &D @WIRE(mode="straight") {%port18::pin %j19};
//   &D @WIRE(mode="straight") {#S2:2 %j19};
//   &D @WIRE(mode="straight") {%j19 %j17};
//   &D @WIRE(mode="straight") {#S3:2 %j17};
//   &D @WIRE(mode="straight") {%j17 %j18};
//   &D @WIRE(mode="straight") {#S4:2 %j18};
//   &D @WIRE(mode="straight") {%j18 %j20};
//   &D @WIRE(mode="straight") {#S5:2 %j20};
//   &D @WIRE(mode="straight") {%j20 #X1:1};
//   &net16 @WIRE(mode="straight") {#X1:2 %j21};
//   &net16 @WIRE(mode="straight") {%j21 #S6:2};
//   &net16 @WIRE(mode="straight") {%j21 (87, -78) #S7:2};
//   &VDD @WIRE(mode="straight") {#M1:3 %vdd1::pin};
//   &VDD @WIRE(mode="straight") {#M19:3 %vdd7::pin};
//   &VDD @WIRE(mode="straight") {#M21:3 %vdd8::pin};
//   &VDD @WIRE(mode="straight") {#M25:3 %vdd9::pin};
//   &VDD @WIRE(mode="straight") {#M43:3 %vdd15::pin};
//   &VDD @WIRE(mode="straight") {#M45:3 %vdd16::pin};
//   &VDD @WIRE(mode="straight") {#M27:3 %vdd10::pin};
//   &VDD @WIRE(mode="straight") {#M31:3 %vdd11::pin};
//   &VDD @WIRE(mode="straight") {#M3:3 %vdd2::pin};
//   &VDD @WIRE(mode="straight") {#M33:3 %vdd12::pin};
//   &VDD @WIRE(mode="straight") {#M37:3 %vdd13::pin};
//   &VDD @WIRE(mode="straight") {#M39:3 %vdd14::pin};
//   &VDD @WIRE(mode="straight") {#M7:3 %vdd3::pin};
//   &VDD @WIRE(mode="straight") {#M9:3 %vdd4::pin};
//   &VDD @WIRE(mode="straight") {#M13:3 %vdd5::pin};
//   &VDD @WIRE(mode="straight") {#M15:3 %vdd6::pin};
//   &I7 @WIRE(mode="straight") {%j22 (65, -55) %j23};
//   &I1b @WIRE(mode="straight") {#M4:1 #M5:1};
//   $JUNCTION @ATTACH (59, -20)(p) => @PLACE(59, -20) => %dot1;
//   &I1b @WIRE(mode="straight") {%j3 #M7:2};
//   $JUNCTION @ATTACH %j12(p) => @PLACE(81, -49) => %dot2;
//   $JUNCTION @ATTACH %j16(p) => @PLACE(85, -60) => %dot3;
//   &I8 @WIRE(mode="straight") {%j10 #M31:2};
//   &I8 @WIRE(mode="straight") {#M28:1 #M29:1};
//   $JUNCTION @ATTACH (120, -49)(p) => @PLACE(120, -49) => %dot4;
//   $JUNCTION @ATTACH (128, -55)(p) => @PLACE(128, -55) => %dot5;
//   $JUNCTION @ATTACH %j9(p) => @PLACE(109, -49) => %dot6;
//   &I5 @WIRE(mode="straight") {%j11 #M30:2};
//   &I7 @WIRE(mode="straight") {%j23 %j13};
//   $JUNCTION @ATTACH %j23(p) => @PLACE(59, -49) => %dot7;
//   &I7 @WIRE(mode="straight") {%j22 #M42:2};
//   $JUNCTION @ATTACH (62, -43)(p) => @PLACE(62, -43) => %dot8;
//   &I2a @WIRE(mode="straight") {#M40:1 #M41:1};
//   $JUNCTION @ATTACH (70, -49)(p) => @PLACE(70, -49) => %dot9;
//   &I7b @WIRE(mode="straight") {#M46:1 #M47:1};
//   $JUNCTION @ATTACH (48, -49)(p) => @PLACE(48, -49) => %dot10;
//   $JUNCTION @ATTACH (62, -26)(p) => @PLACE(62, -26) => %dot11;
//   $JUNCTION @ATTACH %j2(p) => @PLACE(70, -20) => %dot12;
//   &I4 @WIRE(mode="straight") {#M10:1 #M11:1};
//   $JUNCTION @ATTACH (81, -20)(p) => @PLACE(81, -20) => %dot13;
//   $JUNCTION @ATTACH %j7(p) => @PLACE(87, -20) => %dot14;
//   $JUNCTION @ATTACH (112, -26)(p) => @PLACE(112, -26) => %dot15;
//   $JUNCTION @ATTACH %j5(p) => @PLACE(120, -20) => %dot16;
//   &I3b @WIRE(mode="straight") {#M16:1 #M17:1};
//   $JUNCTION @ATTACH (109, -20)(p) => @PLACE(109, -20) => %dot17;
//   &I3b @WIRE(mode="straight") {%j6 #M19:2};
//   &I6 @WIRE(mode="straight") {#M22:1 #M23:1};
//   $JUNCTION @ATTACH (131, -20)(p) => @PLACE(131, -20) => %dot18;
//   $JUNCTION @ATTACH %j8(p) => @PLACE(131, -49) => %dot19;
//   $JUNCTION @ATTACH %j14(p) => @PLACE(135, -49) => %dot20;
//   $JUNCTION @ATTACH %j15(p) => @PLACE(137, -20) => %dot21;
//   &net0 @WIRE(mode="straight") {#M5:3 #M6:1};
//   &net1 @WIRE(mode="straight") {#M29:3 #M30:1};
//   &net2 @WIRE(mode="straight") {#M35:3 #M36:1};
//   &net3 @WIRE(mode="straight") {#M41:3 #M42:1};
//   &net4 @WIRE(mode="straight") {#M47:3 #M48:1};
//   &net5 @WIRE(mode="straight") {#M11:3 #M12:1};
//   &net6 @WIRE(mode="straight") {#M17:3 #M18:1};
//   &net7 @WIRE(mode="straight") {#M23:3 #M24:1};
//   &net8 @WIRE(mode="straight") {#M3:1 #M4:3};
//   &net9 @WIRE(mode="straight") {#M27:1 #M28:3};
//   &net10 @WIRE(mode="straight") {#M33:1 #M34:3};
//   &net11 @WIRE(mode="straight") {#M39:1 #M40:3};
//   &net12 @WIRE(mode="straight") {#M45:1 #M46:3};
//   &net13 @WIRE(mode="straight") {#M9:1 #M10:3};
//   &net14 @WIRE(mode="straight") {#M15:1 #M16:3};
//   &net15 @WIRE(mode="straight") {#M21:1 #M22:3};
//   &I5b @WIRE(mode="straight") {#M34:1 #M35:1};
//   $JUNCTION @ATTACH (98, -49)(p) => @PLACE(98, -49) => %dot22;
//   $JUNCTION @ATTACH %j19(p) => @PLACE(56, -78) => %dot23;
//   $JUNCTION @ATTACH %j17(p) => @PLACE(61, -78) => %dot24;
//   $JUNCTION @ATTACH %j18(p) => @PLACE(66, -78) => %dot25;
//   $JUNCTION @ATTACH %j20(p) => @PLACE(71, -78) => %dot26;
//   &VDD @WIRE(mode="straight") {%vdd17::pin #X2:1};
//   &CLK @WIRE(mode="straight") {#M4:2 %port1::pin};
//   &CLKB @WIRE(mode="straight") {#M23:2 %port8::pin};
//   &Q @WIRE(mode="straight") {%port29::pin #X2:6};
//   &CLK @WIRE(mode="straight") {#M28:2 %port9::pin};
//   &CLKB @WIRE(mode="straight") {#M47:2 %port16::pin};
//   &CLKB @WIRE(mode="straight") {#M29:2 %port10::pin};
//   &CLK @WIRE(mode="straight") {#M34:2 %port11::pin};
//   &CLKB @WIRE(mode="straight") {#M35:2 %port12::pin};
//   &CLK @WIRE(mode="straight") {#M40:2 %port13::pin};
//   &CLKB @WIRE(mode="straight") {#M41:2 %port14::pin};
//   &CLKB @WIRE(mode="straight") {#M5:2 %port2::pin};
//   &CLK @WIRE(mode="straight") {#M46:2 %port15::pin};
//   &CLK @WIRE(mode="straight") {#M10:2 %port3::pin};
//   &CLKB @WIRE(mode="straight") {#M11:2 %port4::pin};
//   &CLK @WIRE(mode="straight") {%port17::pin #S1:3};
//   &CLK @WIRE(mode="straight") {%port28::pin #X2:5};
//   &CLK @WIRE(mode="straight") {#M16:2 %port5::pin};
//   &CLKB @WIRE(mode="straight") {#M17:2 %port6::pin};
//   &CLK @WIRE(mode="straight") {#M22:2 %port7::pin};
//   &NCK @WIRE(mode="straight") {%port19::pin #S2:3};
//   &I1 @WIRE(mode="straight") {%port20::pin #S2:1};
//   &I2 @WIRE(mode="straight") {%port21::pin #S3:1};
//   &I5 @WIRE(mode="straight") {%port22::pin #S4:1};
//   &I3 @WIRE(mode="straight") {%port24::pin #S6:1};
//   &I7 @WIRE(mode="straight") {%port25::pin #S7:1};
//   &I4 @WIRE(mode="straight") {%port26::pin #X2:3};
//   &I8 @WIRE(mode="straight") {%port27::pin #X2:4};
//   &Q @WIRE(mode="straight") {%port23::pin #S5:1};
//   $JUNCTION @ATTACH %j21(p) => @PLACE(81, -78) => %dot27;
//   $JUNCTION @ATTACH %j1(p) => @PLACE(48, -20) => %dot28;
//   $JUNCTION @ATTACH %j4(p) => @PLACE(98, -20) => %dot29;
//   #M1
//       @TEXT("\textbf{\textit{M}}_{\textbf{1}}", key="name", dx=0.4, dy=-0.5, halign="start", valign="baseline", size=1.5116,
//       bold=false, textvisible=true);
//   $CANVAS_LABEL @ATTACH(bind="name") #M1::name(label);
//   #M2
//       @TEXT("\textbf{\textit{M}}_{\textbf{2}}", key="name", dx=-0.5, dy=-0.5, halign="end", valign="baseline", size=1.5116,
//       bold=false, textvisible=true);
//   $CANVAS_LABEL @ATTACH(bind="name") #M2::name(label);
//   #M3
//       @TEXT("\textbf{\textit{M}}_{\textbf{3}}", key="name", dx=0.4, dy=-0.5, halign="start", valign="baseline", size=1.5116,
//       bold=false, textvisible=true);
//   $CANVAS_LABEL @ATTACH(bind="name") #M3::name(label);
//   #M4
//       @TEXT("\textbf{\textit{M}}_{\textbf{4}}", key="name", dx=0.4, dy=-0.5, halign="start", valign="baseline", size=1.5116,
//       bold=false, textvisible=true);
//   $CANVAS_LABEL @ATTACH(bind="name") #M4::name(label);
//   #M5
//       @TEXT("\textbf{\textit{M}}_{\textbf{5}}", key="name", dx=-0.5, dy=-0.5, halign="end", valign="baseline", size=1.5116,
//       bold=false, textvisible=true);
//   $CANVAS_LABEL @ATTACH(bind="name") #M5::name(label);
//   #M6
//       @TEXT("\textbf{\textit{M}}_{\textbf{6}}", key="name", dx=-0.5, dy=-0.5, halign="end", valign="baseline", size=1.5116,
//       bold=false, textvisible=true);
//   $CANVAS_LABEL @ATTACH(bind="name") #M6::name(label);
//   #M7
//       @TEXT("\textbf{\textit{M}}_{\textbf{7}}", key="name", dx=0.4, dy=-0.5, halign="start", valign="baseline", size=1.5116,
//       bold=false, textvisible=true);
//   $CANVAS_LABEL @ATTACH(bind="name") #M7::name(label);
//   #M8
//       @TEXT("\textbf{\textit{M}}_{\textbf{8}}", key="name", dx=-0.5, dy=-0.5, halign="end", valign="baseline", size=1.5116,
//       bold=false, textvisible=true);
//   $CANVAS_LABEL @ATTACH(bind="name") #M8::name(label);
//   #M9
//       @TEXT("\textbf{\textit{M}}_{\textbf{9}}", key="name", dx=0.4, dy=-0.5, halign="start", valign="baseline", size=1.5116,
//       bold=false, textvisible=true);
//   $CANVAS_LABEL @ATTACH(bind="name") #M9::name(label);
//   #M10
//       @TEXT("\textbf{\textit{M}}_{\textbf{10}}", key="name", dx=0.4, dy=-0.5, halign="start", valign="baseline", size=1.5116,
//       bold=false, textvisible=true);
//   $CANVAS_LABEL @ATTACH(bind="name") #M10::name(label);
//   #M11
//       @TEXT("\textbf{\textit{M}}_{\textbf{11}}", key="name", dx=-0.5, dy=-0.5, halign="end", valign="baseline", size=1.5116,
//       bold=false, textvisible=true);
//   $CANVAS_LABEL @ATTACH(bind="name") #M11::name(label);
//   #M12
//       @TEXT("\textbf{\textit{M}}_{\textbf{12}}", key="name", dx=-0.5, dy=-0.5, halign="end", valign="baseline", size=1.5116,
//       bold=false, textvisible=true);
//   $CANVAS_LABEL @ATTACH(bind="name") #M12::name(label);
//   %vdd1 @TEXT("\textbf{\textit{V}}_{\textbf{DD}}", dx=2, dy=1, size=1.5116, bold=false) => %power1;
//   $CANVAS_LABEL @ATTACH(bind="port") %power1(label);
//   %vdd2 @TEXT("\textbf{\textit{V}}_{\textbf{DD}}", dx=2, dy=1, size=1.5116, bold=false) => %power2;
//   $CANVAS_LABEL @ATTACH(bind="port") %power2(label);
//   %vdd3 @TEXT("\textbf{\textit{V}}_{\textbf{DD}}", dx=2, dy=1, size=1.5116, bold=false) => %power3;
//   $CANVAS_LABEL @ATTACH(bind="port") %power3(label);
//   %vdd4 @TEXT("\textbf{\textit{V}}_{\textbf{DD}}", dx=2, dy=1, size=1.5116, bold=false) => %power4;
//   $CANVAS_LABEL @ATTACH(bind="port") %power4(label);
//   %wire1 @TEXT("\textbf{\textit{I1}}", size=1.5116, bold=false) => @PLACE(49, -22) => %label1;
//   $CANVAS_LABEL @ATTACH(bind="net") %label1(label);
//   %port1
//       @TEXT("\textbf{\textit{CLK}}", key="netname", dx=-1, dy=-1.5, halign="end", valign="baseline", size=1.5116, bold=false,
//       textvisible=true);
//   $CANVAS_LABEL @ATTACH(bind="port") %port1::netname(label);
//   %wire2 @TEXT("\textbf{\textit{I1b}}", size=1.5116, bold=false) => @PLACE(65, -17) => %label2;
//   $CANVAS_LABEL @ATTACH(bind="net") %label2(label);
//   %port2
//       @TEXT("\textbf{\textit{CLKB}}", key="netname", dx=0, dy=1, halign="start", valign="baseline", size=1.5116, bold=false,
//       textvisible=true);
//   $CANVAS_LABEL @ATTACH(bind="port") %port2::netname(label);
//   %wire14 @TEXT("\textbf{\textit{I2}}", size=1.5116, bold=false) => @PLACE(70.5, -18.5) => %label3;
//   $CANVAS_LABEL @ATTACH(bind="net") %label3(label);
//   %port3
//       @TEXT("\textbf{\textit{CLK}}", key="netname", dx=-1.5, dy=-2, halign="end", valign="baseline", size=1.5116, bold=false,
//       textvisible=true);
//   $CANVAS_LABEL @ATTACH(bind="port") %port3::netname(label);
//   %wire6 @TEXT("\textbf{\textit{I4}}", size=1.5116, bold=false) => @PLACE(87.5, -18.5) => %label4;
//   $CANVAS_LABEL @ATTACH(bind="net") %label4(label);
//   %port4
//       @TEXT("\textbf{\textit{CLKB}}", key="netname", dx=1.5, dy=0, halign="start", valign="baseline", size=1.5116, bold=false,
//       textvisible=true);
//   $CANVAS_LABEL @ATTACH(bind="port") %port4::netname(label);
//   #M13
//       @TEXT("\textbf{\textit{M}}_{\textbf{13}}", key="name", dx=0.4, dy=-0.5, halign="start", valign="baseline", size=1.5116,
//       bold=false, textvisible=true);
//   $CANVAS_LABEL @ATTACH(bind="name") #M13::name(label);
//   #M14
//       @TEXT("\textbf{\textit{M}}_{\textbf{14}}", key="name", dx=-0.5, dy=-0.5, halign="end", valign="baseline", size=1.5116,
//       bold=false, textvisible=true);
//   $CANVAS_LABEL @ATTACH(bind="name") #M14::name(label);
//   #M15
//       @TEXT("\textbf{\textit{M}}_{\textbf{15}}", key="name", dx=0.4, dy=-0.5, halign="start", valign="baseline", size=1.5116,
//       bold=false, textvisible=true);
//   $CANVAS_LABEL @ATTACH(bind="name") #M15::name(label);
//   #M16
//       @TEXT("\textbf{\textit{M}}_{\textbf{16}}", key="name", dx=0.5, dy=0, halign="start", valign="baseline", size=1.5116,
//       bold=false, textvisible=true);
//   $CANVAS_LABEL @ATTACH(bind="name") #M16::name(label);
//   #M17
//       @TEXT("\textbf{\textit{M}}_{\textbf{17}}", key="name", dx=-0.5, dy=-0.5, halign="end", valign="baseline", size=1.5116,
//       bold=false, textvisible=true);
//   $CANVAS_LABEL @ATTACH(bind="name") #M17::name(label);
//   #M18
//       @TEXT("\textbf{\textit{M}}_{\textbf{18}}", key="name", dx=-0.5, dy=-0.5, halign="end", valign="baseline", size=1.5116,
//       bold=false, textvisible=true);
//   $CANVAS_LABEL @ATTACH(bind="name") #M18::name(label);
//   #M19
//       @TEXT("\textbf{\textit{M}}_{\textbf{19}}", key="name", dx=0.4, dy=-0.5, halign="start", valign="baseline", size=1.5116,
//       bold=false, textvisible=true);
//   $CANVAS_LABEL @ATTACH(bind="name") #M19::name(label);
//   #M20
//       @TEXT("\textbf{\textit{M}}_{\textbf{20}}", key="name", dx=-0.5, dy=-0.5, halign="end", valign="baseline", size=1.5116,
//       bold=false, textvisible=true);
//   $CANVAS_LABEL @ATTACH(bind="name") #M20::name(label);
//   #M21
//       @TEXT("\textbf{\textit{M}}_{\textbf{21}}", key="name", dx=0.4, dy=-0.5, halign="start", valign="baseline", size=1.5116,
//       bold=false, textvisible=true);
//   $CANVAS_LABEL @ATTACH(bind="name") #M21::name(label);
//   #M22
//       @TEXT("\textbf{\textit{M}}_{\textbf{22}}", key="name", dx=0.4, dy=-0.5, halign="start", valign="baseline", size=1.5116,
//       bold=false, textvisible=true);
//   $CANVAS_LABEL @ATTACH(bind="name") #M22::name(label);
//   #M23
//       @TEXT("\textbf{\textit{M}}_{\textbf{23}}", key="name", dx=-0.5, dy=-0.5, halign="end", valign="baseline", size=1.5116,
//       bold=false, textvisible=true);
//   $CANVAS_LABEL @ATTACH(bind="name") #M23::name(label);
//   #M24
//       @TEXT("\textbf{\textit{M}}_{\textbf{24}}", key="name", dx=-0.5, dy=-0.5, halign="end", valign="baseline", size=1.5116,
//       bold=false, textvisible=true);
//   $CANVAS_LABEL @ATTACH(bind="name") #M24::name(label);
//   %vdd5 @TEXT("\textbf{\textit{V}}_{\textbf{DD}}", dx=2, dy=1, size=1.5116, bold=false) => %power5;
//   $CANVAS_LABEL @ATTACH(bind="port") %power5(label);
//   %vdd6 @TEXT("\textbf{\textit{V}}_{\textbf{DD}}", dx=2, dy=1, size=1.5116, bold=false) => %power6;
//   $CANVAS_LABEL @ATTACH(bind="port") %power6(label);
//   %vdd7 @TEXT("\textbf{\textit{V}}_{\textbf{DD}}", dx=2, dy=1, size=1.5116, bold=false) => %power7;
//   $CANVAS_LABEL @ATTACH(bind="port") %power7(label);
//   %vdd8 @TEXT("\textbf{\textit{V}}_{\textbf{DD}}", dx=2, dy=1, size=1.5116, bold=false) => %power8;
//   $CANVAS_LABEL @ATTACH(bind="port") %power8(label);
//   %wire3 @TEXT("\textbf{\textit{I3}}", size=1.5116, bold=false) => @PLACE(99, -22) => %label5;
//   $CANVAS_LABEL @ATTACH(bind="net") %label5(label);
//   %port5
//       @TEXT("\textbf{\textit{CLK}}", key="netname", dx=-1, dy=-1.5, halign="end", valign="baseline", size=1.5116, bold=false,
//       textvisible=true);
//   $CANVAS_LABEL @ATTACH(bind="port") %port5::netname(label);
//   %wire4 @TEXT("\textbf{\textit{I3b}}", size=1.5116, bold=false) => @PLACE(115, -17) => %label6;
//   $CANVAS_LABEL @ATTACH(bind="net") %label6(label);
//   %port6
//       @TEXT("\textbf{\textit{CLKB}}", key="netname", dx=0, dy=1, halign="start", valign="baseline", size=1.5116, bold=false,
//       textvisible=true);
//   $CANVAS_LABEL @ATTACH(bind="port") %port6::netname(label);
//   %wire5 @TEXT("\textbf{\textit{I4}}", size=1.5116, bold=false) => @PLACE(120.5, -18.5) => %label7;
//   $CANVAS_LABEL @ATTACH(bind="net") %label7(label);
//   %port7
//       @TEXT("\textbf{\textit{CLK}}", key="netname", dx=-1.5, dy=-2, halign="end", valign="baseline", size=1.5116, bold=false,
//       textvisible=true);
//   $CANVAS_LABEL @ATTACH(bind="port") %port7::netname(label);
//   %wire10 @TEXT("\textbf{\textit{I6}}", size=1.5116, bold=false) => @PLACE(138.5, -19.5) => %label8;
//   $CANVAS_LABEL @ATTACH(bind="net") %label8(label);
//   %port8
//       @TEXT("\textbf{\textit{CLKB}}", key="netname", dx=1.5, dy=0, halign="start", valign="baseline", size=1.5116, bold=false,
//       textvisible=true);
//   $CANVAS_LABEL @ATTACH(bind="port") %port8::netname(label);
//   #M25
//       @TEXT("\textbf{\textit{M}}_{\textbf{25}}", key="name", dx=-0.4, dy=-0.5, halign="end", valign="baseline", size=1.5116,
//       bold=false, textvisible=true);
//   $CANVAS_LABEL @ATTACH(bind="name") #M25::name(label);
//   #M26
//       @TEXT("\textbf{\textit{M}}_{\textbf{26}}", key="name", dx=0.5, dy=-0.5, halign="start", valign="baseline", size=1.5116,
//       bold=false, textvisible=true);
//   $CANVAS_LABEL @ATTACH(bind="name") #M26::name(label);
//   #M27
//       @TEXT("\textbf{\textit{M}}_{\textbf{27}}", key="name", dx=-0.4, dy=-0.5, halign="end", valign="baseline", size=1.5116,
//       bold=false, textvisible=true);
//   $CANVAS_LABEL @ATTACH(bind="name") #M27::name(label);
//   #M28
//       @TEXT("\textbf{\textit{M}}_{\textbf{28}}", key="name", dx=-0.4, dy=-0.5, halign="end", valign="baseline", size=1.5116,
//       bold=false, textvisible=true);
//   $CANVAS_LABEL @ATTACH(bind="name") #M28::name(label);
//   #M29
//       @TEXT("\textbf{\textit{M}}_{\textbf{29}}", key="name", dx=0.5, dy=-0.5, halign="start", valign="baseline", size=1.5116,
//       bold=false, textvisible=true);
//   $CANVAS_LABEL @ATTACH(bind="name") #M29::name(label);
//   #M30
//       @TEXT("\textbf{\textit{M}}_{\textbf{30}}", key="name", dx=0.5, dy=-0.5, halign="start", valign="baseline", size=1.5116,
//       bold=false, textvisible=true);
//   $CANVAS_LABEL @ATTACH(bind="name") #M30::name(label);
//   #M31
//       @TEXT("\textbf{\textit{M}}_{\textbf{31}}", key="name", dx=-0.4, dy=-0.5, halign="end", valign="baseline", size=1.5116,
//       bold=false, textvisible=true);
//   $CANVAS_LABEL @ATTACH(bind="name") #M31::name(label);
//   #M32
//       @TEXT("\textbf{\textit{M}}_{\textbf{32}}", key="name", dx=0.5, dy=-0.5, halign="start", valign="baseline", size=1.5116,
//       bold=false, textvisible=true);
//   $CANVAS_LABEL @ATTACH(bind="name") #M32::name(label);
//   #M33
//       @TEXT("\textbf{\textit{M}}_{\textbf{33}}", key="name", dx=-0.4, dy=-0.5, halign="end", valign="baseline", size=1.5116,
//       bold=false, textvisible=true);
//   $CANVAS_LABEL @ATTACH(bind="name") #M33::name(label);
//   #M34
//       @TEXT("\textbf{\textit{M}}_{\textbf{34}}", key="name", dx=-0.4, dy=-0.5, halign="end", valign="baseline", size=1.5116,
//       bold=false, textvisible=true);
//   $CANVAS_LABEL @ATTACH(bind="name") #M34::name(label);
//   #M35
//       @TEXT("\textbf{\textit{M}}_{\textbf{35}}", key="name", dx=0.5, dy=-0.5, halign="start", valign="baseline", size=1.5116,
//       bold=false, textvisible=true);
//   $CANVAS_LABEL @ATTACH(bind="name") #M35::name(label);
//   #M36
//       @TEXT("\textbf{\textit{M}}_{\textbf{36}}", key="name", dx=0.5, dy=-0.5, halign="start", valign="baseline", size=1.5116,
//       bold=false, textvisible=true);
//   $CANVAS_LABEL @ATTACH(bind="name") #M36::name(label);
//   %vdd9 @TEXT("\textbf{\textit{V}}_{\textbf{DD}}", dx=-2, dy=1, halign="end", size=1.5116, bold=false) => %power9;
//   $CANVAS_LABEL @ATTACH(bind="port") %power9(label);
//   %vdd10 @TEXT("\textbf{\textit{V}}_{\textbf{DD}}", dx=-2, dy=1, halign="end", size=1.5116, bold=false) => %power10;
//   $CANVAS_LABEL @ATTACH(bind="port") %power10(label);
//   %vdd11 @TEXT("\textbf{\textit{V}}_{\textbf{DD}}", dx=-2, dy=1, halign="end", size=1.5116, bold=false) => %power11;
//   $CANVAS_LABEL @ATTACH(bind="port") %power11(label);
//   %vdd12 @TEXT("\textbf{\textit{V}}_{\textbf{DD}}", dx=-2, dy=1, halign="end", size=1.5116, bold=false) => %power12;
//   $CANVAS_LABEL @ATTACH(bind="port") %power12(label);
//   %port9
//       @TEXT("\textbf{\textit{CLK}}", key="netname", dx=1, dy=-1.5, halign="start", valign="baseline", size=1.5116, bold=false,
//       textvisible=true);
//   $CANVAS_LABEL @ATTACH(bind="port") %port9::netname(label);
//   %wire12 @TEXT("\textbf{\textit{I8}}", halign="end", size=1.5116, bold=false) => @PLACE(115, -44.5) => %label9;
//   $CANVAS_LABEL @ATTACH(bind="net") %label9(label);
//   %port10
//       @TEXT("\textbf{\textit{CLKB}}", key="netname", dx=0, dy=1, halign="end", valign="baseline", size=1.5116, bold=false,
//       textvisible=true);
//   $CANVAS_LABEL @ATTACH(bind="port") %port10::netname(label);
//   %wire7 @TEXT("\textbf{\textit{I5}}", halign="end", size=1.5116, bold=false) => @PLACE(108.5, -47.5) => %label10;
//   $CANVAS_LABEL @ATTACH(bind="net") %label10(label);
//   %port11
//       @TEXT("\textbf{\textit{CLK}}", key="netname", dx=1.5, dy=-2, halign="start", valign="baseline", size=1.5116, bold=false,
//       textvisible=true);
//   $CANVAS_LABEL @ATTACH(bind="port") %port11::netname(label);
//   %wire11 @TEXT("\textbf{\textit{I5b}}", halign="end", size=1.5116, bold=false) => @PLACE(91, -48) => %label11;
//   $CANVAS_LABEL @ATTACH(bind="net") %label11(label);
//   %port12
//       @TEXT("\textbf{\textit{CLKB}}", key="netname", dx=-1.5, dy=0, halign="end", valign="baseline", size=1.5116, bold=false,
//       textvisible=true);
//   $CANVAS_LABEL @ATTACH(bind="port") %port12::netname(label);
//   #M37
//       @TEXT("\textbf{\textit{M}}_{\textbf{37}}", key="name", dx=-0.4, dy=-0.5, halign="end", valign="baseline", size=1.5116,
//       bold=false, textvisible=true);
//   $CANVAS_LABEL @ATTACH(bind="name") #M37::name(label);
//   #M38
//       @TEXT("\textbf{\textit{M}}_{\textbf{38}}", key="name", dx=0.5, dy=-0.5, halign="start", valign="baseline", size=1.5116,
//       bold=false, textvisible=true);
//   $CANVAS_LABEL @ATTACH(bind="name") #M38::name(label);
//   #M39
//       @TEXT("\textbf{\textit{M}}_{\textbf{39}}", key="name", dx=-0.4, dy=-0.5, halign="end", valign="baseline", size=1.5116,
//       bold=false, textvisible=true);
//   $CANVAS_LABEL @ATTACH(bind="name") #M39::name(label);
//   #M40
//       @TEXT("\textbf{\textit{M}}_{\textbf{40}}", key="name", dx=-0.5, dy=0, halign="end", valign="baseline", size=1.5116,
//       bold=false, textvisible=true);
//   $CANVAS_LABEL @ATTACH(bind="name") #M40::name(label);
//   #M41
//       @TEXT("\textbf{\textit{M}}_{\textbf{41}}", key="name", dx=0.5, dy=-0.5, halign="start", valign="baseline", size=1.5116,
//       bold=false, textvisible=true);
//   $CANVAS_LABEL @ATTACH(bind="name") #M41::name(label);
//   #M42
//       @TEXT("\textbf{\textit{M}}_{\textbf{42}}", key="name", dx=0.5, dy=-0.5, halign="start", valign="baseline", size=1.5116,
//       bold=false, textvisible=true);
//   $CANVAS_LABEL @ATTACH(bind="name") #M42::name(label);
//   #M43
//       @TEXT("\textbf{\textit{M}}_{\textbf{43}}", key="name", dx=-0.4, dy=-0.5, halign="end", valign="baseline", size=1.5116,
//       bold=false, textvisible=true);
//   $CANVAS_LABEL @ATTACH(bind="name") #M43::name(label);
//   #M44
//       @TEXT("\textbf{\textit{M}}_{\textbf{44}}", key="name", dx=0.5, dy=-0.5, halign="start", valign="baseline", size=1.5116,
//       bold=false, textvisible=true);
//   $CANVAS_LABEL @ATTACH(bind="name") #M44::name(label);
//   #M45
//       @TEXT("\textbf{\textit{M}}_{\textbf{45}}", key="name", dx=-0.4, dy=-0.5, halign="end", valign="baseline", size=1.5116,
//       bold=false, textvisible=true);
//   $CANVAS_LABEL @ATTACH(bind="name") #M45::name(label);
//   #M46
//       @TEXT("\textbf{\textit{M}}_{\textbf{46}}", key="name", dx=-0.4, dy=-0.5, halign="end", valign="baseline", size=1.5116,
//       bold=false, textvisible=true);
//   $CANVAS_LABEL @ATTACH(bind="name") #M46::name(label);
//   #M47
//       @TEXT("\textbf{\textit{M}}_{\textbf{47}}", key="name", dx=0.5, dy=-0.5, halign="start", valign="baseline", size=1.5116,
//       bold=false, textvisible=true);
//   $CANVAS_LABEL @ATTACH(bind="name") #M47::name(label);
//   #M48
//       @TEXT("\textbf{\textit{M}}_{\textbf{48}}", key="name", dx=0.5, dy=-0.5, halign="start", valign="baseline", size=1.5116,
//       bold=false, textvisible=true);
//   $CANVAS_LABEL @ATTACH(bind="name") #M48::name(label);
//   %vdd13 @TEXT("\textbf{\textit{V}}_{\textbf{DD}}", dx=-2, dy=1, halign="end", size=1.5116, bold=false) => %power13;
//   $CANVAS_LABEL @ATTACH(bind="port") %power13(label);
//   %vdd14 @TEXT("\textbf{\textit{V}}_{\textbf{DD}}", dx=-2, dy=1, halign="end", size=1.5116, bold=false) => %power14;
//   $CANVAS_LABEL @ATTACH(bind="port") %power14(label);
//   %vdd15 @TEXT("\textbf{\textit{V}}_{\textbf{DD}}", dx=-2, dy=1, halign="end", size=1.5116, bold=false) => %power15;
//   $CANVAS_LABEL @ATTACH(bind="port") %power15(label);
//   %vdd16 @TEXT("\textbf{\textit{V}}_{\textbf{DD}}", dx=-2, dy=1, halign="end", size=1.5116, bold=false) => %power16;
//   $CANVAS_LABEL @ATTACH(bind="port") %power16(label);
//   %wire13 @TEXT("\textbf{\textit{I8}}", halign="end", size=1.5116, bold=false) => @PLACE(80, -47) => %label12;
//   $CANVAS_LABEL @ATTACH(bind="net") %label12(label);
//   %port13
//       @TEXT("\textbf{\textit{CLK}}", key="netname", dx=1, dy=-1.5, halign="start", valign="baseline", size=1.5116, bold=false,
//       textvisible=true);
//   $CANVAS_LABEL @ATTACH(bind="port") %port13::netname(label);
//   %wire15 @TEXT("\textbf{\textit{I2a}}", halign="end", size=1.5116, bold=false) => @PLACE(64, -47) => %label13;
//   $CANVAS_LABEL @ATTACH(bind="net") %label13(label);
//   %port14
//       @TEXT("\textbf{\textit{CLKB}}", key="netname", dx=0, dy=1, halign="end", valign="baseline", size=1.5116, bold=false,
//       textvisible=true);
//   $CANVAS_LABEL @ATTACH(bind="port") %port14::netname(label);
//   %wire9 @TEXT("\textbf{\textit{I7}}", halign="end", size=1.5116, bold=false) => @PLACE(58.5, -47.5) => %label14;
//   $CANVAS_LABEL @ATTACH(bind="net") %label14(label);
//   %port15
//       @TEXT("\textbf{\textit{CLK}}", key="netname", dx=1.5, dy=-2, halign="start", valign="baseline", size=1.5116, bold=false,
//       textvisible=true);
//   $CANVAS_LABEL @ATTACH(bind="port") %port15::netname(label);
//   %wire8 @TEXT("\textbf{\textit{I7b}}", halign="end", size=1.5116, bold=false) => @PLACE(41.5, -47.5) => %label15;
//   $CANVAS_LABEL @ATTACH(bind="net") %label15(label);
//   %port16
//       @TEXT("\textbf{\textit{CLKB}}", key="netname", dx=-1.5, dy=0, halign="end", valign="baseline", size=1.5116, bold=false,
//       textvisible=true);
//   $CANVAS_LABEL @ATTACH(bind="port") %port16::netname(label);
//   %port17
//       @TEXT("\textbf{\textit{CLK}}", key="netname", dx=1.5, dy=-0.5, halign="start", valign="baseline", size=1.5116, bold=false,
//       textvisible=true);
//   $CANVAS_LABEL @ATTACH(bind="port") %port17::netname(label);
//   #S2
//       @TEXT("\textbf{\textit{S}}_{\textbf{2}}", key="name", dx=1.5, dy=-0.5, halign="middle", valign="baseline", size=1.5116,
//       bold=false, textvisible=true);
//   $CANVAS_LABEL @ATTACH(bind="name") #S2::name(label);
//   #S3
//       @TEXT("\textbf{\textit{S}}_{\textbf{3}}", key="name", dx=0.7, dy=-0.5, halign="start", valign="baseline", size=1.5116,
//       bold=false, textvisible=true);
//   $CANVAS_LABEL @ATTACH(bind="name") #S3::name(label);
//   #S4
//       @TEXT("\textbf{\textit{S}}_{\textbf{4}}", key="name", dx=0.7, dy=-0.5, halign="start", valign="baseline", size=1.5116,
//       bold=false, textvisible=true);
//   $CANVAS_LABEL @ATTACH(bind="name") #S4::name(label);
//   #S5
//       @TEXT("\textbf{\textit{S}}_{\textbf{5}}", key="name", dx=0.7, dy=-0.5, halign="start", valign="baseline", size=1.5116,
//       bold=false, textvisible=true);
//   $CANVAS_LABEL @ATTACH(bind="name") #S5::name(label);
//   %port18
//       @TEXT("\textbf{\textit{D}}", key="netname", dx=-2, dy=-0.5, halign="end", valign="baseline", size=1.5116, bold=false,
//       textvisible=true);
//   $CANVAS_LABEL @ATTACH(bind="port") %port18::netname(label);
//   %port19
//       @TEXT("\textbf{\textit{NCK}}", key="netname", dx=-2, dy=-0.5, halign="end", valign="baseline", size=1.5116, bold=false,
//       textvisible=true);
//   $CANVAS_LABEL @ATTACH(bind="port") %port19::netname(label);
//   %port20
//       @TEXT("\textbf{\textit{I}}_{\textbf{1}}", key="netname", dx=0, dy=1.9, halign="middle", valign="baseline", size=1.5116,
//       bold=false, textvisible=true);
//   $CANVAS_LABEL @ATTACH(bind="port") %port20::netname(label);
//   %port21
//       @TEXT("\textbf{\textit{I}}_{\textbf{2}}", key="netname", dx=0, dy=1.9, halign="middle", valign="baseline", size=1.5116,
//       bold=false, textvisible=true);
//   $CANVAS_LABEL @ATTACH(bind="port") %port21::netname(label);
//   %port22
//       @TEXT("\textbf{\textit{I}}_{\textbf{5}}", key="netname", dx=0, dy=1.9, halign="middle", valign="baseline", size=1.5116,
//       bold=false, textvisible=true);
//   $CANVAS_LABEL @ATTACH(bind="port") %port22::netname(label);
//   %port23
//       @TEXT("\textbf{\textit{Q}}", key="netname", dx=0, dy=1.9, halign="middle", valign="baseline", size=1.5116, bold=false,
//       textvisible=true);
//   $CANVAS_LABEL @ATTACH(bind="port") %port23::netname(label);
//   #X1
//       @TEXT("\textbf{\textit{X}}_{\textbf{1}}", key="name", dx=-0.5, dy=-2.9, halign="middle", valign="baseline", size=1.5116,
//       bold=false, textvisible=true);
//   $CANVAS_LABEL @ATTACH(bind="name") #X1::name(label);
//   #S6
//       @TEXT("\textbf{\textit{S}}_{\textbf{6}}", key="name", dx=0.7, dy=-0.5, halign="start", valign="baseline", size=1.5116,
//       bold=false, textvisible=true);
//   $CANVAS_LABEL @ATTACH(bind="name") #S6::name(label);
//   #S7
//       @TEXT("\textbf{\textit{S}}_{\textbf{7}}", key="name", dx=0.7, dy=-0.5, halign="start", valign="baseline", size=1.5116,
//       bold=false, textvisible=true);
//   $CANVAS_LABEL @ATTACH(bind="name") #S7::name(label);
//   %port24
//       @TEXT("\textbf{\textit{I}}_{\textbf{3}}", key="netname", dx=0, dy=1.9, halign="middle", valign="baseline", size=1.5116,
//       bold=false, textvisible=true);
//   $CANVAS_LABEL @ATTACH(bind="port") %port24::netname(label);
//   %port25
//       @TEXT("\textbf{\textit{I}}_{\textbf{7}}", key="netname", dx=0, dy=1.9, halign="middle", valign="baseline", size=1.5116,
//       bold=false, textvisible=true);
//   $CANVAS_LABEL @ATTACH(bind="port") %port25::netname(label);
//   #X2
//       @TEXT("\textbf{CG-CE}", key="value", dx=0, dy=-6.5, halign="middle", valign="baseline", size=1.5116, bold=false,
//       textvisible=true);
//   %port26
//       @TEXT("\textbf{\textit{I}}_{\textbf{4}}", key="netname", dx=-2, dy=-0.5, halign="end", valign="baseline", size=1.5116,
//       bold=false, textvisible=true);
//   $CANVAS_LABEL @ATTACH(bind="port") %port26::netname(label);
//   %port27
//       @TEXT("\textbf{\textit{I}}_{\textbf{8}}", key="netname", dx=-2, dy=-0.5, halign="end", valign="baseline", size=1.5116,
//       bold=false, textvisible=true);
//   $CANVAS_LABEL @ATTACH(bind="port") %port27::netname(label);
//   %vdd17 @TEXT("\textbf{\textit{V}}_{\textbf{DD}}", dx=1, dy=3, halign="end", size=1.5116, bold=false) => %power17;
//   $CANVAS_LABEL @ATTACH(bind="port") %power17(label);
//   %port28
//       @TEXT("\textbf{\textit{CLK}}", key="netname", dx=2, dy=-0.5, halign="start", valign="baseline", size=1.5116, bold=false,
//       textvisible=true);
//   $CANVAS_LABEL @ATTACH(bind="port") %port28::netname(label);
//   %port29
//       @TEXT("\textbf{\textit{Q}}", key="netname", dx=2, dy=-0.5, halign="start", valign="baseline", size=1.5116, bold=false,
//       textvisible=true);
//   $CANVAS_LABEL @ATTACH(bind="port") %port29::netname(label);
//   %vdd1 @TEXT("${p}", key="netname", textvisible=false);
//   %vdd2 @TEXT("${p}", key="netname", textvisible=false);
//   %vdd3 @TEXT("${p}", key="netname", textvisible=false);
//   %vdd4 @TEXT("${p}", key="netname", textvisible=false);
//   %vdd5 @TEXT("${p}", key="netname", textvisible=false);
//   %vdd6 @TEXT("${p}", key="netname", textvisible=false);
//   %vdd7 @TEXT("${p}", key="netname", textvisible=false);
//   %vdd8 @TEXT("${p}", key="netname", textvisible=false);
//   %vdd9 @TEXT("${p}", key="netname", textvisible=false);
//   %vdd10 @TEXT("${p}", key="netname", textvisible=false);
//   %vdd11 @TEXT("${p}", key="netname", textvisible=false);
//   %vdd12 @TEXT("${p}", key="netname", textvisible=false);
//   %vdd13 @TEXT("${p}", key="netname", textvisible=false);
//   %vdd14 @TEXT("${p}", key="netname", textvisible=false);
//   %vdd15 @TEXT("${p}", key="netname", textvisible=false);
//   %vdd16 @TEXT("${p}", key="netname", textvisible=false);
//   %vdd17 @TEXT("${p}", key="netname", textvisible=false)
// }
ends dut
