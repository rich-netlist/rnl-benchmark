simulator lang=spectre
// @RNL(type="header") {
//   @VERSION("0.4");
//   @USE-PACKAGE(name="rnl-std-style", version="0.4");
//   @USE-PACKAGE(name="rnl-std-basic", version="0.4");
//   @USE-PACKAGE(name="rnl-std-semiconductors", version="0.4");
//   @USE-PACKAGE(name="rnl-std-no-labels", version="0.4");
//   @USE-PACKAGE(name="analog-canvas-extensions", version="0.7")
// }

subckt astra_021_cmos_nonoverlap_clock (vdd VSS clk a b)
CA (net0 VSS) capacitor c=200f
CB (net1 VSS) capacitor c=200f
CLA (a VSS) capacitor c=100f
CLB (b VSS) capacitor c=100f
M1 (clkb clk vdd vdd) APMOS l=1u w=10u
M10 (b ad VSS VSS) ANMOS l=1u w=4u
M11 (net0 a vdd vdd) APMOS l=1u w=10u
M12 (net0 a VSS VSS) ANMOS l=1u w=4u
M13 (ad net0 vdd vdd) APMOS l=1u w=10u
M14 (ad net0 VSS VSS) ANMOS l=1u w=4u
M15 (net1 b vdd vdd) APMOS l=1u w=10u
M16 (net1 b VSS VSS) ANMOS l=1u w=4u
M17 (bd net1 vdd vdd) APMOS l=1u w=10u
M18 (bd net1 VSS VSS) ANMOS l=1u w=4u
M2 (clkb clk VSS VSS) ANMOS l=1u w=4u
M3 (net2 clkb vdd vdd) APMOS l=1u w=20u
M4 (a bd net2 vdd) APMOS l=1u w=20u
M5 (a clkb VSS VSS) ANMOS l=1u w=4u
M6 (a bd VSS VSS) ANMOS l=1u w=4u
M7 (net3 clk vdd vdd) APMOS l=1u w=20u
M8 (b ad net3 vdd) APMOS l=1u w=20u
M9 (b clk VSS VSS) ANMOS l=1u w=4u
// @RNL(author="analog-canvas") {
//   $CANVAS_TYPESETTING @ATTACH(subscript_italic=false, subscript_after_first=true) #(level);
//   #M1 @SET-SYMBOL(terminals=[[1, "d"], [2, "g"], [3, "s"], [4, "b"]]) $CANVAS_PMOS_4TERM => @PLACE(8, -20) => @ORIENT("R0");
//   #M2 @SET-SYMBOL(terminals=[[1, "d"], [2, "g"], [3, "s"], [4, "b"]]) $CANVAS_NMOS_4TERM => @PLACE(8, -28) => @ORIENT("R0");
//   $SUPPLY @ATTACH &vdd(p) => @SET-SYMBOL $SUPPLY_SYMBOL => @PLACE(8, -17) => @ORIENT("R0") => %vdd1;
//   $GROUND @ATTACH &VSS(p) => @SET-SYMBOL $GROUND_SYMBOL => @PLACE(8, -31) => @ORIENT("R0") => %gnd1;
//   $IO_PORT @ATTACH &clk(p) => @SET-SYMBOL $IO_PORT_SYMBOL => @PLACE(3, -24) => @ORIENT("R0") => %port1;
//   #M3 @SET-SYMBOL(terminals=[[1, "d"], [2, "g"], [3, "s"], [4, "b"]]) $CANVAS_PMOS_4TERM => @PLACE(31, 0) => @ORIENT("R0");
//   #M4 @SET-SYMBOL(terminals=[[1, "d"], [2, "g"], [3, "s"], [4, "b"]]) $CANVAS_PMOS_4TERM => @PLACE(31, -8) => @ORIENT("R0");
//   #M5 @SET-SYMBOL(terminals=[[1, "d"], [2, "g"], [3, "s"], [4, "b"]]) $CANVAS_NMOS_4TERM => @PLACE(31, -21) => @ORIENT("R0");
//   #M6 @SET-SYMBOL(terminals=[[1, "d"], [2, "g"], [3, "s"], [4, "b"]]) $CANVAS_NMOS_4TERM => @PLACE(44, -21) => @ORIENT("R0");
//   $SUPPLY @ATTACH &vdd(p) => @SET-SYMBOL $SUPPLY_SYMBOL => @PLACE(31, 3) => @ORIENT("R0") => %vdd2;
//   $GROUND @ATTACH &VSS(p) => @SET-SYMBOL $GROUND_SYMBOL => @PLACE(31, -24) => @ORIENT("R0") => %gnd2;
//   $GROUND @ATTACH &VSS(p) => @SET-SYMBOL $GROUND_SYMBOL => @PLACE(44, -24) => @ORIENT("R0") => %gnd3;
//   #M7 @SET-SYMBOL(terminals=[[1, "d"], [2, "g"], [3, "s"], [4, "b"]]) $CANVAS_PMOS_4TERM => @PLACE(31, -36) => @ORIENT("R0");
//   #M8 @SET-SYMBOL(terminals=[[1, "d"], [2, "g"], [3, "s"], [4, "b"]]) $CANVAS_PMOS_4TERM => @PLACE(31, -44) => @ORIENT("R0");
//   #M9 @SET-SYMBOL(terminals=[[1, "d"], [2, "g"], [3, "s"], [4, "b"]]) $CANVAS_NMOS_4TERM => @PLACE(31, -57) => @ORIENT("R0");
//   #M10 @SET-SYMBOL(terminals=[[1, "d"], [2, "g"], [3, "s"], [4, "b"]]) $CANVAS_NMOS_4TERM => @PLACE(44, -57) => @ORIENT("R0");
//   $SUPPLY @ATTACH &vdd(p) => @SET-SYMBOL $SUPPLY_SYMBOL => @PLACE(31, -33) => @ORIENT("R0") => %vdd3;
//   $GROUND @ATTACH &VSS(p) => @SET-SYMBOL $GROUND_SYMBOL => @PLACE(31, -60) => @ORIENT("R0") => %gnd4;
//   $GROUND @ATTACH &VSS(p) => @SET-SYMBOL $GROUND_SYMBOL => @PLACE(44, -60) => @ORIENT("R0") => %gnd5;
//   #M11 @SET-SYMBOL(terminals=[[1, "d"], [2, "g"], [3, "s"], [4, "b"]]) $CANVAS_PMOS_4TERM => @PLACE(66, -11) => @ORIENT("R0");
//   #M12 @SET-SYMBOL(terminals=[[1, "d"], [2, "g"], [3, "s"], [4, "b"]]) $CANVAS_NMOS_4TERM => @PLACE(66, -19) => @ORIENT("R0");
//   $SUPPLY @ATTACH &vdd(p) => @SET-SYMBOL $SUPPLY_SYMBOL => @PLACE(66, -8) => @ORIENT("R0") => %vdd4;
//   $GROUND @ATTACH &VSS(p) => @SET-SYMBOL $GROUND_SYMBOL => @PLACE(66, -22) => @ORIENT("R0") => %gnd6;
//   #M13 @SET-SYMBOL(terminals=[[1, "d"], [2, "g"], [3, "s"], [4, "b"]]) $CANVAS_PMOS_4TERM => @PLACE(87, -11) => @ORIENT("R0");
//   #M14 @SET-SYMBOL(terminals=[[1, "d"], [2, "g"], [3, "s"], [4, "b"]]) $CANVAS_NMOS_4TERM => @PLACE(87, -19) => @ORIENT("R0");
//   $SUPPLY @ATTACH &vdd(p) => @SET-SYMBOL $SUPPLY_SYMBOL => @PLACE(87, -8) => @ORIENT("R0") => %vdd5;
//   $GROUND @ATTACH &VSS(p) => @SET-SYMBOL $GROUND_SYMBOL => @PLACE(87, -22) => @ORIENT("R0") => %gnd7;
//   #M15 @SET-SYMBOL(terminals=[[1, "d"], [2, "g"], [3, "s"], [4, "b"]]) $CANVAS_PMOS_4TERM => @PLACE(66, -47) => @ORIENT("R0");
//   #M16 @SET-SYMBOL(terminals=[[1, "d"], [2, "g"], [3, "s"], [4, "b"]]) $CANVAS_NMOS_4TERM => @PLACE(66, -55) => @ORIENT("R0");
//   $SUPPLY @ATTACH &vdd(p) => @SET-SYMBOL $SUPPLY_SYMBOL => @PLACE(66, -44) => @ORIENT("R0") => %vdd6;
//   $GROUND @ATTACH &VSS(p) => @SET-SYMBOL $GROUND_SYMBOL => @PLACE(66, -58) => @ORIENT("R0") => %gnd8;
//   #M17 @SET-SYMBOL(terminals=[[1, "d"], [2, "g"], [3, "s"], [4, "b"]]) $CANVAS_PMOS_4TERM => @PLACE(87, -47) => @ORIENT("R0");
//   #M18 @SET-SYMBOL(terminals=[[1, "d"], [2, "g"], [3, "s"], [4, "b"]]) $CANVAS_NMOS_4TERM => @PLACE(87, -55) => @ORIENT("R0");
//   $SUPPLY @ATTACH &vdd(p) => @SET-SYMBOL $SUPPLY_SYMBOL => @PLACE(87, -44) => @ORIENT("R0") => %vdd7;
//   $GROUND @ATTACH &VSS(p) => @SET-SYMBOL $GROUND_SYMBOL => @PLACE(87, -58) => @ORIENT("R0") => %gnd9;
//   #CA @SET-SYMBOL $CAPACITOR => @PLACE(74, -22) => @ORIENT("R0");
//   $GROUND @ATTACH &VSS(p) => @SET-SYMBOL $GROUND_SYMBOL => @PLACE(74, -25) => @ORIENT("R0") => %gnd10;
//   #CB @SET-SYMBOL $CAPACITOR => @PLACE(74, -58) => @ORIENT("R0");
//   $GROUND @ATTACH &VSS(p) => @SET-SYMBOL $GROUND_SYMBOL => @PLACE(74, -61) => @ORIENT("R0") => %gnd11;
//   #CLA @SET-SYMBOL $CAPACITOR => @PLACE(52, -22) => @ORIENT("R0");
//   $GROUND @ATTACH &VSS(p) => @SET-SYMBOL $GROUND_SYMBOL => @PLACE(52, -25) => @ORIENT("R0") => %gnd12;
//   #CLB @SET-SYMBOL $CAPACITOR => @PLACE(52, -58) => @ORIENT("R0");
//   $GROUND @ATTACH &VSS(p) => @SET-SYMBOL $GROUND_SYMBOL => @PLACE(52, -61) => @ORIENT("R0") => %gnd13;
//   $IO_PORT @ATTACH &a(p) => @SET-SYMBOL $IO_PORT_SYMBOL => @PLACE(52, -10) => @ORIENT("MYR90") => %port2;
//   $IO_PORT @ATTACH &b(p) => @SET-SYMBOL $IO_PORT_SYMBOL => @PLACE(52, -46) => @ORIENT("MYR90") => %port3;
//   %j1 = (4, -20);
//   %j2 = (4, -24);
//   %j3 = (4, -28);
//   %j4 = (8, -24);
//   %j5 = (10, -24);
//   %j6 = (31, -15);
//   %j7 = (44, -15);
//   %j8 = (27, 0);
//   %j9 = (27, -8);
//   %j10 = (27, -21);
//   %j11 = (40, -21);
//   %j12 = (31, -51);
//   %j13 = (44, -51);
//   %j14 = (27, -36);
//   %j15 = (27, -44);
//   %j16 = (27, -57);
//   %j17 = (40, -57);
//   %j18 = (62, -11);
//   %j19 = (62, -15);
//   %j20 = (62, -19);
//   %j21 = (66, -15);
//   %j22 = (83, -11);
//   %j23 = (83, -15);
//   %j24 = (83, -19);
//   %j25 = (87, -15);
//   %j26 = (89, -15);
//   %j27 = (62, -47);
//   %j28 = (62, -51);
//   %j29 = (62, -55);
//   %j30 = (66, -51);
//   %j31 = (83, -47);
//   %j32 = (83, -51);
//   %j33 = (83, -55);
//   %j34 = (87, -51);
//   %j35 = (89, -51);
//   %j36 = (52, -15);
//   %j37 = (52, -51);
//   %j38 = (74, -15);
//   %j39 = (74, -51);
//   &vdd @WIRE(mode="straight") {%vdd1::pin #M1:3};
//   &VSS @WIRE(mode="straight") {#M2:3 %gnd1::pin};
//   &clk @WIRE(mode="straight") {#M1:2 %j1};
//   &clk @WIRE(mode="straight") {%j1 %j2};
//   &clk @WIRE(mode="straight") {%j2 %j3};
//   &clk @WIRE(mode="straight") {%j3 #M2:2};
//   &clkb @WIRE(mode="straight") {#M1:1 %j4};
//   &clkb @WIRE(mode="straight") {%j4 #M2:1};
//   &clk @WIRE(mode="straight") {%port1::pin %j2};
//   &clkb @WIRE(mode="straight") {%j4 %j5};
//   &vdd @WIRE(mode="straight") {%vdd2::pin #M3:3};
//   &net2 @WIRE(mode="straight") {#M3:1 #M4:3};
//   &a @WIRE(mode="straight") {#M4:1 %j6};
//   &a @WIRE(mode="straight") {%j6 #M5:1};
//   &a @WIRE(mode="straight") {%j6 %j7};
//   &a @WIRE(mode="straight") {%j7 #M6:1};
//   &VSS @WIRE(mode="straight") {#M5:3 %gnd2::pin};
//   &VSS @WIRE(mode="straight") {#M6:3 %gnd3::pin};
//   &clkb @WIRE(mode="straight") {#M3:2 %j8};
//   &bd @WIRE(mode="straight") {#M4:2 %j9};
//   &clkb @WIRE(mode="straight") {#M5:2 %j10};
//   &bd @WIRE(mode="straight") {#M6:2 %j11};
//   &vdd @WIRE(mode="straight") {%vdd3::pin #M7:3};
//   &net3 @WIRE(mode="straight") {#M7:1 #M8:3};
//   &b @WIRE(mode="straight") {#M8:1 %j12};
//   &b @WIRE(mode="straight") {%j12 #M9:1};
//   &b @WIRE(mode="straight") {%j12 %j13};
//   &b @WIRE(mode="straight") {%j13 #M10:1};
//   &VSS @WIRE(mode="straight") {#M9:3 %gnd4::pin};
//   &VSS @WIRE(mode="straight") {#M10:3 %gnd5::pin};
//   &clk @WIRE(mode="straight") {#M7:2 %j14};
//   &ad @WIRE(mode="straight") {#M8:2 %j15};
//   &clk @WIRE(mode="straight") {#M9:2 %j16};
//   &ad @WIRE(mode="straight") {#M10:2 %j17};
//   &vdd @WIRE(mode="straight") {%vdd4::pin #M11:3};
//   &VSS @WIRE(mode="straight") {#M12:3 %gnd6::pin};
//   &a @WIRE(mode="straight") {#M11:2 %j18};
//   &a @WIRE(mode="straight") {%j18 %j19};
//   &a @WIRE(mode="straight") {%j19 %j20};
//   &a @WIRE(mode="straight") {%j20 #M12:2};
//   &net0 @WIRE(mode="straight") {#M11:1 %j21};
//   &net0 @WIRE(mode="straight") {%j21 #M12:1};
//   &vdd @WIRE(mode="straight") {%vdd5::pin #M13:3};
//   &VSS @WIRE(mode="straight") {#M14:3 %gnd7::pin};
//   &net0 @WIRE(mode="straight") {#M13:2 %j22};
//   &net0 @WIRE(mode="straight") {%j22 %j23};
//   &net0 @WIRE(mode="straight") {%j23 %j24};
//   &net0 @WIRE(mode="straight") {%j24 #M14:2};
//   &ad @WIRE(mode="straight") {#M13:1 %j25};
//   &ad @WIRE(mode="straight") {%j25 #M14:1};
//   &ad @WIRE(mode="straight") {%j25 %j26};
//   &vdd @WIRE(mode="straight") {%vdd6::pin #M15:3};
//   &VSS @WIRE(mode="straight") {#M16:3 %gnd8::pin};
//   &b @WIRE(mode="straight") {#M15:2 %j27};
//   &b @WIRE(mode="straight") {%j27 %j28};
//   &b @WIRE(mode="straight") {%j28 %j29};
//   &b @WIRE(mode="straight") {%j29 #M16:2};
//   &net1 @WIRE(mode="straight") {#M15:1 %j30};
//   &net1 @WIRE(mode="straight") {%j30 #M16:1};
//   &vdd @WIRE(mode="straight") {%vdd7::pin #M17:3};
//   &VSS @WIRE(mode="straight") {#M18:3 %gnd9::pin};
//   &net1 @WIRE(mode="straight") {#M17:2 %j31};
//   &net1 @WIRE(mode="straight") {%j31 %j32};
//   &net1 @WIRE(mode="straight") {%j32 %j33};
//   &net1 @WIRE(mode="straight") {%j33 #M18:2};
//   &bd @WIRE(mode="straight") {#M17:1 %j34};
//   &bd @WIRE(mode="straight") {%j34 #M18:1};
//   &bd @WIRE(mode="straight") {%j34 %j35};
//   &a @WIRE(mode="straight") {%j7 %j36};
//   &a @WIRE(mode="straight") {%j36 %j19};
//   &b @WIRE(mode="straight") {%j13 %j37};
//   &b @WIRE(mode="straight") {%j37 %j28};
//   &net0 @WIRE(mode="straight") {%j21 %j38};
//   &net0 @WIRE(mode="straight") {%j38 %j23};
//   &net1 @WIRE(mode="straight") {%j30 %j39};
//   &net1 @WIRE(mode="straight") {%j39 %j32};
//   &VSS @WIRE(mode="straight") {#CA:2 %gnd10::pin};
//   &net0 @WIRE(mode="straight") {%j38 #CA:1};
//   &VSS @WIRE(mode="straight") {#CB:2 %gnd11::pin};
//   &net1 @WIRE(mode="straight") {%j39 #CB:1};
//   &VSS @WIRE(mode="straight") {#CLA:2 %gnd12::pin};
//   &a @WIRE(mode="straight") {%j36 #CLA:1};
//   &VSS @WIRE(mode="straight") {#CLB:2 %gnd13::pin};
//   &b @WIRE(mode="straight") {%j37 #CLB:1};
//   &a @WIRE(mode="straight") {%j36 %port2::pin};
//   &b @WIRE(mode="straight") {%j37 %port3::pin};
//   $JUNCTION @ATTACH %j6(p) => @PLACE(31, -15) => %dot1;
//   $JUNCTION @ATTACH %j7(p) => @PLACE(44, -15) => %dot2;
//   $JUNCTION @ATTACH %j36(p) => @PLACE(52, -15) => %dot3;
//   $JUNCTION @ATTACH %j19(p) => @PLACE(62, -15) => %dot4;
//   $JUNCTION @ATTACH %j25(p) => @PLACE(87, -15) => %dot5;
//   $JUNCTION @ATTACH %j21(p) => @PLACE(66, -15) => %dot6;
//   $JUNCTION @ATTACH %j38(p) => @PLACE(74, -15) => %dot7;
//   $JUNCTION @ATTACH %j23(p) => @PLACE(83, -15) => %dot8;
//   $JUNCTION @ATTACH %j12(p) => @PLACE(31, -51) => %dot9;
//   $JUNCTION @ATTACH %j13(p) => @PLACE(44, -51) => %dot10;
//   $JUNCTION @ATTACH %j37(p) => @PLACE(52, -51) => %dot11;
//   $JUNCTION @ATTACH %j28(p) => @PLACE(62, -51) => %dot12;
//   $JUNCTION @ATTACH %j34(p) => @PLACE(87, -51) => %dot13;
//   $JUNCTION @ATTACH %j30(p) => @PLACE(66, -51) => %dot14;
//   $JUNCTION @ATTACH %j39(p) => @PLACE(74, -51) => %dot15;
//   $JUNCTION @ATTACH %j32(p) => @PLACE(83, -51) => %dot16;
//   $JUNCTION @ATTACH %j2(p) => @PLACE(4, -24) => %dot17;
//   $JUNCTION @ATTACH %j4(p) => @PLACE(8, -24) => %dot18;
//   #M1
//       @TEXT("\textbf{\textit{M}}_{\textbf{1}}", key="name", dx=0.4, dy=-0.5, halign="start", valign="baseline", size=1.5116,
//       bold=false, textvisible=true);
//   $CANVAS_LABEL @ATTACH(bind="name") #M1::name(label);
//   #M2
//       @TEXT("\textbf{\textit{M}}_{\textbf{2}}", key="name", dx=0.5, dy=-0.5, halign="start", valign="baseline", size=1.5116,
//       bold=false, textvisible=true);
//   $CANVAS_LABEL @ATTACH(bind="name") #M2::name(label);
//   &vdd @TEXT("\textbf{\textit{v}}_{\textbf{dd}}", halign="middle", size=1.5116, bold=false) => @PLACE(8, -14) => %power1;
//   $CANVAS_LABEL @ATTACH(bind="net") %power1(label);
//   %port1 @TEXT("\textbf{\textit{clk}}", dx=-1.4, dy=-0.4, halign="end", size=1.5116, bold=false) => %label1;
//   $CANVAS_LABEL @ATTACH(bind="port") %label1(label);
//   &clkb @TEXT("\textbf{\textit{clkb}}", size=1.5116, bold=false) => @PLACE(11, -24.4) => %label2;
//   $CANVAS_LABEL @ATTACH(bind="net") %label2(label);
//   #M3
//       @TEXT("\textbf{\textit{M}}_{\textbf{3}}", key="name", dx=0.4, dy=-0.5, halign="start", valign="baseline", size=1.5116,
//       bold=false, textvisible=true);
//   $CANVAS_LABEL @ATTACH(bind="name") #M3::name(label);
//   #M4
//       @TEXT("\textbf{\textit{M}}_{\textbf{4}}", key="name", dx=0.4, dy=-0.5, halign="start", valign="baseline", size=1.5116,
//       bold=false, textvisible=true);
//   $CANVAS_LABEL @ATTACH(bind="name") #M4::name(label);
//   #M5
//       @TEXT("\textbf{\textit{M}}_{\textbf{5}}", key="name", dx=0.5, dy=-0.5, halign="start", valign="baseline", size=1.5116,
//       bold=false, textvisible=true);
//   $CANVAS_LABEL @ATTACH(bind="name") #M5::name(label);
//   #M6
//       @TEXT("\textbf{\textit{M}}_{\textbf{6}}", key="name", dx=0.5, dy=-0.5, halign="start", valign="baseline", size=1.5116,
//       bold=false, textvisible=true);
//   $CANVAS_LABEL @ATTACH(bind="name") #M6::name(label);
//   &vdd @TEXT("\textbf{\textit{v}}_{\textbf{dd}}", halign="middle", size=1.5116, bold=false) => @PLACE(31, 6) => %power2;
//   $CANVAS_LABEL @ATTACH(bind="net") %power2(label);
//   &clkb @TEXT("\textbf{\textit{clkb}}", halign="end", size=1.5116, bold=false) => @PLACE(26, -0.4) => %label3;
//   $CANVAS_LABEL @ATTACH(bind="net") %label3(label);
//   &bd @TEXT("\textbf{\textit{bd}}", halign="end", size=1.5116, bold=false) => @PLACE(26, -8.4) => %label4;
//   $CANVAS_LABEL @ATTACH(bind="net") %label4(label);
//   &clkb @TEXT("\textbf{\textit{clkb}}", halign="end", size=1.5116, bold=false) => @PLACE(26, -21.4) => %label5;
//   $CANVAS_LABEL @ATTACH(bind="net") %label5(label);
//   &bd @TEXT("\textbf{\textit{bd}}", halign="end", size=1.5116, bold=false) => @PLACE(39, -21.4) => %label6;
//   $CANVAS_LABEL @ATTACH(bind="net") %label6(label);
//   #M7
//       @TEXT("\textbf{\textit{M}}_{\textbf{7}}", key="name", dx=0.4, dy=-0.5, halign="start", valign="baseline", size=1.5116,
//       bold=false, textvisible=true);
//   $CANVAS_LABEL @ATTACH(bind="name") #M7::name(label);
//   #M8
//       @TEXT("\textbf{\textit{M}}_{\textbf{8}}", key="name", dx=0.4, dy=-0.5, halign="start", valign="baseline", size=1.5116,
//       bold=false, textvisible=true);
//   $CANVAS_LABEL @ATTACH(bind="name") #M8::name(label);
//   #M9
//       @TEXT("\textbf{\textit{M}}_{\textbf{9}}", key="name", dx=0.5, dy=-0.5, halign="start", valign="baseline", size=1.5116,
//       bold=false, textvisible=true);
//   $CANVAS_LABEL @ATTACH(bind="name") #M9::name(label);
//   #M10
//       @TEXT("\textbf{\textit{M}}_{\textbf{10}}", key="name", dx=0.5, dy=-0.5, halign="start", valign="baseline", size=1.5116,
//       bold=false, textvisible=true);
//   $CANVAS_LABEL @ATTACH(bind="name") #M10::name(label);
//   &vdd @TEXT("\textbf{\textit{v}}_{\textbf{dd}}", halign="middle", size=1.5116, bold=false) => @PLACE(31, -30) => %power3;
//   $CANVAS_LABEL @ATTACH(bind="net") %power3(label);
//   &clk @TEXT("\textbf{\textit{clk}}", halign="end", size=1.5116, bold=false) => @PLACE(26, -36.4) => %label7;
//   $CANVAS_LABEL @ATTACH(bind="net") %label7(label);
//   &ad @TEXT("\textbf{\textit{ad}}", halign="end", size=1.5116, bold=false) => @PLACE(26, -44.4) => %label8;
//   $CANVAS_LABEL @ATTACH(bind="net") %label8(label);
//   &clk @TEXT("\textbf{\textit{clk}}", halign="end", size=1.5116, bold=false) => @PLACE(26, -57.4) => %label9;
//   $CANVAS_LABEL @ATTACH(bind="net") %label9(label);
//   &ad @TEXT("\textbf{\textit{ad}}", halign="end", size=1.5116, bold=false) => @PLACE(39, -57.4) => %label10;
//   $CANVAS_LABEL @ATTACH(bind="net") %label10(label);
//   #M11
//       @TEXT("\textbf{\textit{M}}_{\textbf{11}}", key="name", dx=0.4, dy=-0.5, halign="start", valign="baseline", size=1.5116,
//       bold=false, textvisible=true);
//   $CANVAS_LABEL @ATTACH(bind="name") #M11::name(label);
//   #M12
//       @TEXT("\textbf{\textit{M}}_{\textbf{12}}", key="name", dx=0.5, dy=-0.5, halign="start", valign="baseline", size=1.5116,
//       bold=false, textvisible=true);
//   $CANVAS_LABEL @ATTACH(bind="name") #M12::name(label);
//   &vdd @TEXT("\textbf{\textit{v}}_{\textbf{dd}}", halign="middle", size=1.5116, bold=false) => @PLACE(66, -5) => %power4;
//   $CANVAS_LABEL @ATTACH(bind="net") %power4(label);
//   #M13
//       @TEXT("\textbf{\textit{M}}_{\textbf{13}}", key="name", dx=0.4, dy=-0.5, halign="start", valign="baseline", size=1.5116,
//       bold=false, textvisible=true);
//   $CANVAS_LABEL @ATTACH(bind="name") #M13::name(label);
//   #M14
//       @TEXT("\textbf{\textit{M}}_{\textbf{14}}", key="name", dx=0.5, dy=-0.5, halign="start", valign="baseline", size=1.5116,
//       bold=false, textvisible=true);
//   $CANVAS_LABEL @ATTACH(bind="name") #M14::name(label);
//   &vdd @TEXT("\textbf{\textit{v}}_{\textbf{dd}}", halign="middle", size=1.5116, bold=false) => @PLACE(87, -5) => %power5;
//   $CANVAS_LABEL @ATTACH(bind="net") %power5(label);
//   &ad @TEXT("\textbf{\textit{ad}}", size=1.5116, bold=false) => @PLACE(90, -15.4) => %label11;
//   $CANVAS_LABEL @ATTACH(bind="net") %label11(label);
//   #M15
//       @TEXT("\textbf{\textit{M}}_{\textbf{15}}", key="name", dx=0.4, dy=-0.5, halign="start", valign="baseline", size=1.5116,
//       bold=false, textvisible=true);
//   $CANVAS_LABEL @ATTACH(bind="name") #M15::name(label);
//   #M16
//       @TEXT("\textbf{\textit{M}}_{\textbf{16}}", key="name", dx=0.5, dy=-0.5, halign="start", valign="baseline", size=1.5116,
//       bold=false, textvisible=true);
//   $CANVAS_LABEL @ATTACH(bind="name") #M16::name(label);
//   &vdd @TEXT("\textbf{\textit{v}}_{\textbf{dd}}", halign="middle", size=1.5116, bold=false) => @PLACE(66, -41) => %power6;
//   $CANVAS_LABEL @ATTACH(bind="net") %power6(label);
//   #M17
//       @TEXT("\textbf{\textit{M}}_{\textbf{17}}", key="name", dx=0.4, dy=-0.5, halign="start", valign="baseline", size=1.5116,
//       bold=false, textvisible=true);
//   $CANVAS_LABEL @ATTACH(bind="name") #M17::name(label);
//   #M18
//       @TEXT("\textbf{\textit{M}}_{\textbf{18}}", key="name", dx=0.5, dy=-0.5, halign="start", valign="baseline", size=1.5116,
//       bold=false, textvisible=true);
//   $CANVAS_LABEL @ATTACH(bind="name") #M18::name(label);
//   &vdd @TEXT("\textbf{\textit{v}}_{\textbf{dd}}", halign="middle", size=1.5116, bold=false) => @PLACE(87, -41) => %power7;
//   $CANVAS_LABEL @ATTACH(bind="net") %power7(label);
//   &bd @TEXT("\textbf{\textit{bd}}", size=1.5116, bold=false) => @PLACE(90, -51.4) => %label12;
//   $CANVAS_LABEL @ATTACH(bind="net") %label12(label);
//   #CA
//       @TEXT("\textbf{\textit{C}}_{\textbf{A}}", key="name", dx=1.2, dy=-0.5, halign="start", valign="baseline", size=1.5116,
//       bold=false, textvisible=true);
//   $CANVAS_LABEL @ATTACH(bind="name") #CA::name(label);
//   #CA
//       @TEXT("\textbf{200f}", key="value", dx=1.2, dy=-2.5, halign="start", valign="baseline", size=1.5116, bold=false,
//       textvisible=true);
//   $CANVAS_LABEL @ATTACH(bind="value") #CA::value(label);
//   #CB
//       @TEXT("\textbf{\textit{C}}_{\textbf{B}}", key="name", dx=1.2, dy=-0.5, halign="start", valign="baseline", size=1.5116,
//       bold=false, textvisible=true);
//   $CANVAS_LABEL @ATTACH(bind="name") #CB::name(label);
//   #CB
//       @TEXT("\textbf{200f}", key="value", dx=1.2, dy=-2.5, halign="start", valign="baseline", size=1.5116, bold=false,
//       textvisible=true);
//   $CANVAS_LABEL @ATTACH(bind="value") #CB::value(label);
//   #CLA
//       @TEXT("\textbf{\textit{C}}_{\textbf{LA}}", key="name", dx=1.2, dy=-0.5, halign="start", valign="baseline", size=1.5116,
//       bold=false, textvisible=true);
//   $CANVAS_LABEL @ATTACH(bind="name") #CLA::name(label);
//   #CLA
//       @TEXT("\textbf{100f}", key="value", dx=1.2, dy=-2.5, halign="start", valign="baseline", size=1.5116, bold=false,
//       textvisible=true);
//   $CANVAS_LABEL @ATTACH(bind="value") #CLA::value(label);
//   #CLB
//       @TEXT("\textbf{\textit{C}}_{\textbf{LB}}", key="name", dx=1.2, dy=-0.5, halign="start", valign="baseline", size=1.5116,
//       bold=false, textvisible=true);
//   $CANVAS_LABEL @ATTACH(bind="name") #CLB::name(label);
//   #CLB
//       @TEXT("\textbf{100f}", key="value", dx=1.2, dy=-2.5, halign="start", valign="baseline", size=1.5116, bold=false,
//       textvisible=true);
//   $CANVAS_LABEL @ATTACH(bind="value") #CLB::value(label);
//   %port2 @TEXT("\textbf{\textit{a}}", dx=0, dy=1.8, halign="middle", size=1.5116, bold=false) => %label13;
//   $CANVAS_LABEL @ATTACH(bind="port") %label13(label);
//   %port3 @TEXT("\textbf{\textit{b}}", dx=0, dy=1.8, halign="middle", size=1.5116, bold=false) => %label14;
//   $CANVAS_LABEL @ATTACH(bind="port") %label14(label);
//   %vdd1 @TEXT("${p}", key="netname", textvisible=false);
//   %port1 @TEXT("${p}", key="netname", textvisible=false);
//   %vdd2 @TEXT("${p}", key="netname", textvisible=false);
//   %vdd3 @TEXT("${p}", key="netname", textvisible=false);
//   %vdd4 @TEXT("${p}", key="netname", textvisible=false);
//   %vdd5 @TEXT("${p}", key="netname", textvisible=false);
//   %vdd6 @TEXT("${p}", key="netname", textvisible=false);
//   %vdd7 @TEXT("${p}", key="netname", textvisible=false);
//   %port2 @TEXT("${p}", key="netname", textvisible=false);
//   %port3 @TEXT("${p}", key="netname", textvisible=false)
// }
ends astra_021_cmos_nonoverlap_clock
