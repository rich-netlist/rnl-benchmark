simulator lang=spectre
// @RNL(type="header") {
//   @VERSION("0.4");
//   @USE-PACKAGE(name="rnl-std-style", version="0.4");
//   @USE-PACKAGE(name="rnl-std-basic", version="0.4");
//   @USE-PACKAGE(name="rnl-std-semiconductors", version="0.4");
//   @USE-PACKAGE(name="rnl-std-no-labels", version="0.4");
//   @USE-PACKAGE(name="analog-canvas-extensions", version="0.7")
// }

subckt dut (VDD VSS Vb Vin Vout)
M1 (Vout Vin VSS VSS) sky130_fd_pr__nfet_01v8 l=0.15 w=1 nf=1 m=1
M2 (Vout Vb VDD VDD) sky130_fd_pr__pfet_01v8 l=0.15 w=1 nf=1 m=1
// @RNL(author="analog-canvas") {
//   %dut_SYMBOL = @DEFINE-SYMBOL(box=[-6, -5, 6, 5]) {
//     (0, 5) @PIN(terminal="VDD", label="\textbf{\textit{V}}_{\textbf{DD}}", direction="up");
//     (-6, 0) @PIN(terminal="Vb", label="\textbf{\textit{V}}_{\textbf{b}}", direction="left");
//     (-6, -2) @PIN(terminal="Vin", label="\textbf{\textit{V}}_{\textbf{in}}", direction="left");
//     (6, -1) @PIN(terminal="Vout", label="\textbf{\textit{V}}_{\textbf{out}}", direction="right");
//     (0, 0) @RECTANGLE(width=10, height=8);
//     @LINE {(0, 5) (0, 4)};
//     @LINE {(-6, 0) (-5, 0)};
//     @LINE {(-6, -2) (-5, -2)};
//     @LINE {(6, -1) (5, -1)}
//   };
//   # @SET-SYMBOL %dut_SYMBOL;
//   $CANVAS_TYPESETTING @ATTACH(subscript_italic=false) #(level);
//   #M2 @SET-SYMBOL(terminals=[[1, "d"], [2, "g"], [3, "s"]]) $PMOS => @PLACE(21, -10) => @ORIENT("R0");
//   #M1 @SET-SYMBOL(terminals=[[1, "d"], [2, "g"], [3, "s"]]) $NMOS => @PLACE(21, -20) => @ORIENT("R0");
//   $SUPPLY @ATTACH &VDD(p) => @SET-SYMBOL $SUPPLY_SYMBOL => @PLACE(21, -8) => @ORIENT("R0") => %vdd1;
//   $GROUND @ATTACH &VSS(p) => @SET-SYMBOL $GROUND_SYMBOL => @PLACE(21, -22) => @ORIENT("R0") => %gnd1;
//   $IO_PORT @ATTACH &Vb(p) => @SET-SYMBOL $IO_PORT_SYMBOL => @PLACE(18, -10) => @ORIENT("R0") => %port1;
//   $IO_PORT @ATTACH &Vin(p) => @SET-SYMBOL $IO_PORT_SYMBOL => @PLACE(18, -20) => @ORIENT("R0") => %port2;
//   $IO_PORT @ATTACH &Vout(p) => @SET-SYMBOL $IO_PORT_SYMBOL => @PLACE(26, -15) => @ORIENT("R180") => %port3;
//   %j1 = (21, -15);
//   &Vout @WIRE(mode="straight") {#M2:1 %j1};
//   &Vout @WIRE(mode="straight") {%j1 #M1:1};
//   &Vout @WIRE(mode="straight") {%port3::pin %j1};
//   &Vin @WIRE(mode="straight") {#M1:2 %port2::pin};
//   &VDD @WIRE(mode="straight") {#M2:3 %vdd1::pin};
//   &Vb @WIRE(mode="straight") {%port1::pin #M2:2};
//   $JUNCTION @ATTACH %j1(p) => @PLACE(21, -15) => %dot1;
//   &VSS @WIRE(mode="straight") {%gnd1::pin #M1:3};
//   #M2
//       @TEXT("\textbf{\textit{M}}_{\textbf{2}}", key="name", dx=0.4, dy=-0.5, halign="start", valign="baseline", size=1.5116,
//       bold=false, textvisible=true);
//   $CANVAS_LABEL @ATTACH(bind="name") #M2::name(label);
//   #M1
//       @TEXT("\textbf{\textit{M}}_{\textbf{1}}", key="name", dx=0.5, dy=-0.5, halign="start", valign="baseline", size=1.5116,
//       bold=false, textvisible=true);
//   $CANVAS_LABEL @ATTACH(bind="name") #M1::name(label);
//   %vdd1 @TEXT("\textbf{\textit{V}}_{\textbf{DD}}", dx=-1.5, dy=3.6, size=1.5116, bold=false) => %power1;
//   $CANVAS_LABEL @ATTACH(bind="port") %power1(label);
//   %port1
//       @TEXT("\textbf{\textit{V}}_{\textbf{b}}", key="netname", dx=-2, dy=-0.5, halign="end", valign="baseline", size=1.5116,
//       bold=false, textvisible=true);
//   $CANVAS_LABEL @ATTACH(bind="port") %port1::netname(label);
//   %port2
//       @TEXT("\textbf{\textit{V}}_{\textbf{in}}", key="netname", dx=-2, dy=-0.5, halign="end", valign="baseline", size=1.5116,
//       bold=false, textvisible=true);
//   $CANVAS_LABEL @ATTACH(bind="port") %port2::netname(label);
//   %port3
//       @TEXT("\textbf{\textit{V}}_{\textbf{out}}", key="netname", dx=2, dy=-0.5, halign="start", valign="baseline", size=1.5116,
//       bold=false, textvisible=true);
//   $CANVAS_LABEL @ATTACH(bind="port") %port3::netname(label);
//   %vdd1 @TEXT("${p}", key="netname", textvisible=false)
// }
ends dut
